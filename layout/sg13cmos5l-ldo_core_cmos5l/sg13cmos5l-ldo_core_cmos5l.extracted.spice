* extracted by klt extract --deck sg13cmos5l

* cell sg13cmos5l_ldo_core_cmos5l
* pin EN
* pin IBIAS
* pin VIN
* pin VOUT
* pin VREF
* pin VSS
.SUBCKT sg13cmos5l_ldo_core_cmos5l EN IBIAS VIN VOUT VREF VSS
* device instance $1 r0 *1 101,2.5 nfet
M$1 N1 N1 VSS VSS nfet L=1U W=5U AS=2.5P AD=2.5P PS=11U PD=11U
* device instance $2 r0 *1 106,2.5 nfet
M$2 G1 N1 VSS VSS nfet L=1U W=5U AS=2.5P AD=2.5P PS=11U PD=11U
* device instance $3 r0 *1 111,10 nfet
M$3 EAOUT G1 VSS VSS nfet L=1U W=20U AS=10P AD=10P PS=41U PD=41U
* device instance $4 r0 *1 0.75,12.5 pfet
M$4 VOUT EAOUT VIN VIN pfet L=0.5U W=25U AS=12.5P AD=6.25P PS=51U PD=25.5U
* device instance $5 r0 *1 1.75,12.5 pfet
M$5 VIN EAOUT VOUT VIN pfet L=0.5U W=25U AS=6.25P AD=6.25P PS=25.5U PD=25.5U
* device instance $6 r0 *1 2.75,12.5 pfet
M$6 VOUT EAOUT VIN VIN pfet L=0.5U W=25U AS=6.25P AD=6.25P PS=25.5U PD=25.5U
* device instance $7 r0 *1 3.75,12.5 pfet
M$7 VIN EAOUT VOUT VIN pfet L=0.5U W=25U AS=6.25P AD=6.25P PS=25.5U PD=25.5U
* device instance $8 r0 *1 4.75,12.5 pfet
M$8 VOUT EAOUT VIN VIN pfet L=0.5U W=25U AS=6.25P AD=6.25P PS=25.5U PD=25.5U
* device instance $9 r0 *1 5.75,12.5 pfet
M$9 VIN EAOUT VOUT VIN pfet L=0.5U W=25U AS=6.25P AD=6.25P PS=25.5U PD=25.5U
* device instance $10 r0 *1 6.75,12.5 pfet
M$10 VOUT EAOUT VIN VIN pfet L=0.5U W=25U AS=6.25P AD=6.25P PS=25.5U PD=25.5U
* device instance $11 r0 *1 7.75,12.5 pfet
M$11 VIN EAOUT VOUT VIN pfet L=0.5U W=25U AS=6.25P AD=6.25P PS=25.5U PD=25.5U
* device instance $12 r0 *1 8.75,12.5 pfet
M$12 VOUT EAOUT VIN VIN pfet L=0.5U W=25U AS=6.25P AD=6.25P PS=25.5U PD=25.5U
* device instance $13 r0 *1 9.75,12.5 pfet
M$13 VIN EAOUT VOUT VIN pfet L=0.5U W=25U AS=6.25P AD=6.25P PS=25.5U PD=25.5U
* device instance $14 r0 *1 10.75,12.5 pfet
M$14 VOUT EAOUT VIN VIN pfet L=0.5U W=25U AS=6.25P AD=6.25P PS=25.5U PD=25.5U
* device instance $15 r0 *1 11.75,12.5 pfet
M$15 VIN EAOUT VOUT VIN pfet L=0.5U W=25U AS=6.25P AD=6.25P PS=25.5U PD=25.5U
* device instance $16 r0 *1 12.75,12.5 pfet
M$16 VOUT EAOUT VIN VIN pfet L=0.5U W=25U AS=6.25P AD=6.25P PS=25.5U PD=25.5U
* device instance $17 r0 *1 13.75,12.5 pfet
M$17 VIN EAOUT VOUT VIN pfet L=0.5U W=25U AS=6.25P AD=6.25P PS=25.5U PD=25.5U
* device instance $18 r0 *1 14.75,12.5 pfet
M$18 VOUT EAOUT VIN VIN pfet L=0.5U W=25U AS=6.25P AD=6.25P PS=25.5U PD=25.5U
* device instance $19 r0 *1 15.75,12.5 pfet
M$19 VIN EAOUT VOUT VIN pfet L=0.5U W=25U AS=6.25P AD=6.25P PS=25.5U PD=25.5U
* device instance $20 r0 *1 16.75,12.5 pfet
M$20 VOUT EAOUT VIN VIN pfet L=0.5U W=25U AS=6.25P AD=6.25P PS=25.5U PD=25.5U
* device instance $21 r0 *1 17.75,12.5 pfet
M$21 VIN EAOUT VOUT VIN pfet L=0.5U W=25U AS=6.25P AD=6.25P PS=25.5U PD=25.5U
* device instance $22 r0 *1 18.75,12.5 pfet
M$22 VOUT EAOUT VIN VIN pfet L=0.5U W=25U AS=6.25P AD=6.25P PS=25.5U PD=25.5U
* device instance $23 r0 *1 19.75,12.5 pfet
M$23 VIN EAOUT VOUT VIN pfet L=0.5U W=25U AS=6.25P AD=6.25P PS=25.5U PD=25.5U
* device instance $24 r0 *1 20.75,12.5 pfet
M$24 VOUT EAOUT VIN VIN pfet L=0.5U W=25U AS=6.25P AD=6.25P PS=25.5U PD=25.5U
* device instance $25 r0 *1 21.75,12.5 pfet
M$25 VIN EAOUT VOUT VIN pfet L=0.5U W=25U AS=6.25P AD=6.25P PS=25.5U PD=25.5U
* device instance $26 r0 *1 22.75,12.5 pfet
M$26 VOUT EAOUT VIN VIN pfet L=0.5U W=25U AS=6.25P AD=6.25P PS=25.5U PD=25.5U
* device instance $27 r0 *1 23.75,12.5 pfet
M$27 VIN EAOUT VOUT VIN pfet L=0.5U W=25U AS=6.25P AD=6.25P PS=25.5U PD=25.5U
* device instance $28 r0 *1 24.75,12.5 pfet
M$28 VOUT EAOUT VIN VIN pfet L=0.5U W=25U AS=6.25P AD=6.25P PS=25.5U PD=25.5U
* device instance $29 r0 *1 25.75,12.5 pfet
M$29 VIN EAOUT VOUT VIN pfet L=0.5U W=25U AS=6.25P AD=6.25P PS=25.5U PD=25.5U
* device instance $30 r0 *1 26.75,12.5 pfet
M$30 VOUT EAOUT VIN VIN pfet L=0.5U W=25U AS=6.25P AD=6.25P PS=25.5U PD=25.5U
* device instance $31 r0 *1 27.75,12.5 pfet
M$31 VIN EAOUT VOUT VIN pfet L=0.5U W=25U AS=6.25P AD=12.5P PS=25.5U PD=51U
* device instance $32 r0 *1 46.5,2.5 pfet
M$32 IBIAS IBIAS VIN VIN pfet L=2U W=5U AS=2.5P AD=2.5P PS=11U PD=11U
* device instance $33 r0 *1 54.5,2.5 pfet
M$33 TAIL IBIAS VIN VIN pfet L=2U W=5U AS=2.5P AD=1.25P PS=11U PD=5.5U
* device instance $34 r0 *1 57,2.5 pfet
M$34 VIN IBIAS TAIL VIN pfet L=2U W=5U AS=1.25P AD=1.25P PS=5.5U PD=5.5U
* device instance $35 r0 *1 59.5,2.5 pfet
M$35 TAIL IBIAS VIN VIN pfet L=2U W=5U AS=1.25P AD=2.5P PS=5.5U PD=11U
* device instance $36 r0 *1 67.5,2.5 pfet
M$36 EAOUT IBIAS VIN VIN pfet L=2U W=5U AS=2.5P AD=1.25P PS=11U PD=5.5U
* device instance $37 r0 *1 70,2.5 pfet
M$37 VIN IBIAS EAOUT VIN pfet L=2U W=5U AS=1.25P AD=1.25P PS=5.5U PD=5.5U
* device instance $38 r0 *1 72.5,2.5 pfet
M$38 EAOUT IBIAS VIN VIN pfet L=2U W=5U AS=1.25P AD=1.25P PS=5.5U PD=5.5U
* device instance $39 r0 *1 75,2.5 pfet
M$39 VIN IBIAS EAOUT VIN pfet L=2U W=5U AS=1.25P AD=1.25P PS=5.5U PD=5.5U
* device instance $40 r0 *1 77.5,2.5 pfet
M$40 EAOUT IBIAS VIN VIN pfet L=2U W=5U AS=1.25P AD=1.25P PS=5.5U PD=5.5U
* device instance $41 r0 *1 80,2.5 pfet
M$41 VIN IBIAS EAOUT VIN pfet L=2U W=5U AS=1.25P AD=2.5P PS=5.5U PD=11U
* device instance $42 r0 *1 89,10 pfet
M$42 G1 FB TAIL TAIL pfet L=1U W=20U AS=10P AD=10P PS=41U PD=41U
* device instance $43 r0 *1 94,10 pfet
M$43 N1 VREF TAIL TAIL pfet L=1U W=20U AS=10P AD=10P PS=41U PD=41U
* device instance $44 r0 *1 178.75,10 pfet
M$44 EAOUT EN VIN VIN pfet L=0.5U W=20U AS=10P AD=5P PS=41U PD=20.5U
* device instance $45 r0 *1 179.75,10 pfet
M$45 VIN EN EAOUT VIN pfet L=0.5U W=20U AS=5P AD=10P PS=20.5U PD=41U
* device instance $46 r0 *1 187.75,2.5 pfet
M$46 IBIAS EN VIN VIN pfet L=0.5U W=5U AS=2.5P AD=2.5P PS=11U PD=11U
* device instance $47 r0 *1 0.75,74.5 pfet
M$47 VOUT EAOUT VIN VIN pfet L=0.5U W=25U AS=12.5P AD=6.25P PS=51U PD=25.5U
* device instance $48 r0 *1 1.75,74.5 pfet
M$48 VIN EAOUT VOUT VIN pfet L=0.5U W=25U AS=6.25P AD=6.25P PS=25.5U PD=25.5U
* device instance $49 r0 *1 2.75,74.5 pfet
M$49 VOUT EAOUT VIN VIN pfet L=0.5U W=25U AS=6.25P AD=6.25P PS=25.5U PD=25.5U
* device instance $50 r0 *1 3.75,74.5 pfet
M$50 VIN EAOUT VOUT VIN pfet L=0.5U W=25U AS=6.25P AD=6.25P PS=25.5U PD=25.5U
* device instance $51 r0 *1 4.75,74.5 pfet
M$51 VOUT EAOUT VIN VIN pfet L=0.5U W=25U AS=6.25P AD=6.25P PS=25.5U PD=25.5U
* device instance $52 r0 *1 5.75,74.5 pfet
M$52 VIN EAOUT VOUT VIN pfet L=0.5U W=25U AS=6.25P AD=6.25P PS=25.5U PD=25.5U
* device instance $53 r0 *1 6.75,74.5 pfet
M$53 VOUT EAOUT VIN VIN pfet L=0.5U W=25U AS=6.25P AD=6.25P PS=25.5U PD=25.5U
* device instance $54 r0 *1 7.75,74.5 pfet
M$54 VIN EAOUT VOUT VIN pfet L=0.5U W=25U AS=6.25P AD=6.25P PS=25.5U PD=25.5U
* device instance $55 r0 *1 8.75,74.5 pfet
M$55 VOUT EAOUT VIN VIN pfet L=0.5U W=25U AS=6.25P AD=6.25P PS=25.5U PD=25.5U
* device instance $56 r0 *1 9.75,74.5 pfet
M$56 VIN EAOUT VOUT VIN pfet L=0.5U W=25U AS=6.25P AD=6.25P PS=25.5U PD=25.5U
* device instance $57 r0 *1 10.75,74.5 pfet
M$57 VOUT EAOUT VIN VIN pfet L=0.5U W=25U AS=6.25P AD=6.25P PS=25.5U PD=25.5U
* device instance $58 r0 *1 11.75,74.5 pfet
M$58 VIN EAOUT VOUT VIN pfet L=0.5U W=25U AS=6.25P AD=6.25P PS=25.5U PD=25.5U
* device instance $59 r0 *1 12.75,74.5 pfet
M$59 VOUT EAOUT VIN VIN pfet L=0.5U W=25U AS=6.25P AD=6.25P PS=25.5U PD=25.5U
* device instance $60 r0 *1 13.75,74.5 pfet
M$60 VIN EAOUT VOUT VIN pfet L=0.5U W=25U AS=6.25P AD=6.25P PS=25.5U PD=25.5U
* device instance $61 r0 *1 14.75,74.5 pfet
M$61 VOUT EAOUT VIN VIN pfet L=0.5U W=25U AS=6.25P AD=6.25P PS=25.5U PD=25.5U
* device instance $62 r0 *1 15.75,74.5 pfet
M$62 VIN EAOUT VOUT VIN pfet L=0.5U W=25U AS=6.25P AD=6.25P PS=25.5U PD=25.5U
* device instance $63 r0 *1 16.75,74.5 pfet
M$63 VOUT EAOUT VIN VIN pfet L=0.5U W=25U AS=6.25P AD=6.25P PS=25.5U PD=25.5U
* device instance $64 r0 *1 17.75,74.5 pfet
M$64 VIN EAOUT VOUT VIN pfet L=0.5U W=25U AS=6.25P AD=6.25P PS=25.5U PD=25.5U
* device instance $65 r0 *1 18.75,74.5 pfet
M$65 VOUT EAOUT VIN VIN pfet L=0.5U W=25U AS=6.25P AD=6.25P PS=25.5U PD=25.5U
* device instance $66 r0 *1 19.75,74.5 pfet
M$66 VIN EAOUT VOUT VIN pfet L=0.5U W=25U AS=6.25P AD=6.25P PS=25.5U PD=25.5U
* device instance $67 r0 *1 20.75,74.5 pfet
M$67 VOUT EAOUT VIN VIN pfet L=0.5U W=25U AS=6.25P AD=6.25P PS=25.5U PD=25.5U
* device instance $68 r0 *1 21.75,74.5 pfet
M$68 VIN EAOUT VOUT VIN pfet L=0.5U W=25U AS=6.25P AD=6.25P PS=25.5U PD=25.5U
* device instance $69 r0 *1 22.75,74.5 pfet
M$69 VOUT EAOUT VIN VIN pfet L=0.5U W=25U AS=6.25P AD=6.25P PS=25.5U PD=25.5U
* device instance $70 r0 *1 23.75,74.5 pfet
M$70 VIN EAOUT VOUT VIN pfet L=0.5U W=25U AS=6.25P AD=6.25P PS=25.5U PD=25.5U
* device instance $71 r0 *1 24.75,74.5 pfet
M$71 VOUT EAOUT VIN VIN pfet L=0.5U W=25U AS=6.25P AD=6.25P PS=25.5U PD=25.5U
* device instance $72 r0 *1 25.75,74.5 pfet
M$72 VIN EAOUT VOUT VIN pfet L=0.5U W=25U AS=6.25P AD=6.25P PS=25.5U PD=25.5U
* device instance $73 r0 *1 26.75,74.5 pfet
M$73 VOUT EAOUT VIN VIN pfet L=0.5U W=25U AS=6.25P AD=6.25P PS=25.5U PD=25.5U
* device instance $74 r0 *1 27.75,74.5 pfet
M$74 VIN EAOUT VOUT VIN pfet L=0.5U W=25U AS=6.25P AD=12.5P PS=25.5U PD=51U
* device instance $75 r0 *1 0.75,43.5 pfet
M$75 VOUT EAOUT VIN VIN pfet L=0.5U W=25U AS=12.5P AD=6.25P PS=51U PD=25.5U
* device instance $76 r0 *1 1.75,43.5 pfet
M$76 VIN EAOUT VOUT VIN pfet L=0.5U W=25U AS=6.25P AD=6.25P PS=25.5U PD=25.5U
* device instance $77 r0 *1 2.75,43.5 pfet
M$77 VOUT EAOUT VIN VIN pfet L=0.5U W=25U AS=6.25P AD=6.25P PS=25.5U PD=25.5U
* device instance $78 r0 *1 3.75,43.5 pfet
M$78 VIN EAOUT VOUT VIN pfet L=0.5U W=25U AS=6.25P AD=6.25P PS=25.5U PD=25.5U
* device instance $79 r0 *1 4.75,43.5 pfet
M$79 VOUT EAOUT VIN VIN pfet L=0.5U W=25U AS=6.25P AD=6.25P PS=25.5U PD=25.5U
* device instance $80 r0 *1 5.75,43.5 pfet
M$80 VIN EAOUT VOUT VIN pfet L=0.5U W=25U AS=6.25P AD=6.25P PS=25.5U PD=25.5U
* device instance $81 r0 *1 6.75,43.5 pfet
M$81 VOUT EAOUT VIN VIN pfet L=0.5U W=25U AS=6.25P AD=6.25P PS=25.5U PD=25.5U
* device instance $82 r0 *1 7.75,43.5 pfet
M$82 VIN EAOUT VOUT VIN pfet L=0.5U W=25U AS=6.25P AD=6.25P PS=25.5U PD=25.5U
* device instance $83 r0 *1 8.75,43.5 pfet
M$83 VOUT EAOUT VIN VIN pfet L=0.5U W=25U AS=6.25P AD=6.25P PS=25.5U PD=25.5U
* device instance $84 r0 *1 9.75,43.5 pfet
M$84 VIN EAOUT VOUT VIN pfet L=0.5U W=25U AS=6.25P AD=6.25P PS=25.5U PD=25.5U
* device instance $85 r0 *1 10.75,43.5 pfet
M$85 VOUT EAOUT VIN VIN pfet L=0.5U W=25U AS=6.25P AD=6.25P PS=25.5U PD=25.5U
* device instance $86 r0 *1 11.75,43.5 pfet
M$86 VIN EAOUT VOUT VIN pfet L=0.5U W=25U AS=6.25P AD=6.25P PS=25.5U PD=25.5U
* device instance $87 r0 *1 12.75,43.5 pfet
M$87 VOUT EAOUT VIN VIN pfet L=0.5U W=25U AS=6.25P AD=6.25P PS=25.5U PD=25.5U
* device instance $88 r0 *1 13.75,43.5 pfet
M$88 VIN EAOUT VOUT VIN pfet L=0.5U W=25U AS=6.25P AD=6.25P PS=25.5U PD=25.5U
* device instance $89 r0 *1 14.75,43.5 pfet
M$89 VOUT EAOUT VIN VIN pfet L=0.5U W=25U AS=6.25P AD=6.25P PS=25.5U PD=25.5U
* device instance $90 r0 *1 15.75,43.5 pfet
M$90 VIN EAOUT VOUT VIN pfet L=0.5U W=25U AS=6.25P AD=6.25P PS=25.5U PD=25.5U
* device instance $91 r0 *1 16.75,43.5 pfet
M$91 VOUT EAOUT VIN VIN pfet L=0.5U W=25U AS=6.25P AD=6.25P PS=25.5U PD=25.5U
* device instance $92 r0 *1 17.75,43.5 pfet
M$92 VIN EAOUT VOUT VIN pfet L=0.5U W=25U AS=6.25P AD=6.25P PS=25.5U PD=25.5U
* device instance $93 r0 *1 18.75,43.5 pfet
M$93 VOUT EAOUT VIN VIN pfet L=0.5U W=25U AS=6.25P AD=6.25P PS=25.5U PD=25.5U
* device instance $94 r0 *1 19.75,43.5 pfet
M$94 VIN EAOUT VOUT VIN pfet L=0.5U W=25U AS=6.25P AD=6.25P PS=25.5U PD=25.5U
* device instance $95 r0 *1 20.75,43.5 pfet
M$95 VOUT EAOUT VIN VIN pfet L=0.5U W=25U AS=6.25P AD=6.25P PS=25.5U PD=25.5U
* device instance $96 r0 *1 21.75,43.5 pfet
M$96 VIN EAOUT VOUT VIN pfet L=0.5U W=25U AS=6.25P AD=6.25P PS=25.5U PD=25.5U
* device instance $97 r0 *1 22.75,43.5 pfet
M$97 VOUT EAOUT VIN VIN pfet L=0.5U W=25U AS=6.25P AD=6.25P PS=25.5U PD=25.5U
* device instance $98 r0 *1 23.75,43.5 pfet
M$98 VIN EAOUT VOUT VIN pfet L=0.5U W=25U AS=6.25P AD=6.25P PS=25.5U PD=25.5U
* device instance $99 r0 *1 24.75,43.5 pfet
M$99 VOUT EAOUT VIN VIN pfet L=0.5U W=25U AS=6.25P AD=6.25P PS=25.5U PD=25.5U
* device instance $100 r0 *1 25.75,43.5 pfet
M$100 VIN EAOUT VOUT VIN pfet L=0.5U W=25U AS=6.25P AD=6.25P PS=25.5U PD=25.5U
* device instance $101 r0 *1 26.75,43.5 pfet
M$101 VOUT EAOUT VIN VIN pfet L=0.5U W=25U AS=6.25P AD=6.25P PS=25.5U PD=25.5U
* device instance $102 r0 *1 27.75,43.5 pfet
M$102 VIN EAOUT VOUT VIN pfet L=0.5U W=25U AS=6.25P AD=12.5P PS=25.5U PD=51U
* device instance $103 r0 *1 0.75,105.5 pfet
M$103 VOUT EAOUT VIN VIN pfet L=0.5U W=25U AS=12.5P AD=6.25P PS=51U PD=25.5U
* device instance $104 r0 *1 1.75,105.5 pfet
M$104 VIN EAOUT VOUT VIN pfet L=0.5U W=25U AS=6.25P AD=6.25P PS=25.5U PD=25.5U
* device instance $105 r0 *1 2.75,105.5 pfet
M$105 VOUT EAOUT VIN VIN pfet L=0.5U W=25U AS=6.25P AD=6.25P PS=25.5U PD=25.5U
* device instance $106 r0 *1 3.75,105.5 pfet
M$106 VIN EAOUT VOUT VIN pfet L=0.5U W=25U AS=6.25P AD=6.25P PS=25.5U PD=25.5U
* device instance $107 r0 *1 4.75,105.5 pfet
M$107 VOUT EAOUT VIN VIN pfet L=0.5U W=25U AS=6.25P AD=6.25P PS=25.5U PD=25.5U
* device instance $108 r0 *1 5.75,105.5 pfet
M$108 VIN EAOUT VOUT VIN pfet L=0.5U W=25U AS=6.25P AD=6.25P PS=25.5U PD=25.5U
* device instance $109 r0 *1 6.75,105.5 pfet
M$109 VOUT EAOUT VIN VIN pfet L=0.5U W=25U AS=6.25P AD=6.25P PS=25.5U PD=25.5U
* device instance $110 r0 *1 7.75,105.5 pfet
M$110 VIN EAOUT VOUT VIN pfet L=0.5U W=25U AS=6.25P AD=6.25P PS=25.5U PD=25.5U
* device instance $111 r0 *1 8.75,105.5 pfet
M$111 VOUT EAOUT VIN VIN pfet L=0.5U W=25U AS=6.25P AD=6.25P PS=25.5U PD=25.5U
* device instance $112 r0 *1 9.75,105.5 pfet
M$112 VIN EAOUT VOUT VIN pfet L=0.5U W=25U AS=6.25P AD=6.25P PS=25.5U PD=25.5U
* device instance $113 r0 *1 10.75,105.5 pfet
M$113 VOUT EAOUT VIN VIN pfet L=0.5U W=25U AS=6.25P AD=6.25P PS=25.5U PD=25.5U
* device instance $114 r0 *1 11.75,105.5 pfet
M$114 VIN EAOUT VOUT VIN pfet L=0.5U W=25U AS=6.25P AD=6.25P PS=25.5U PD=25.5U
* device instance $115 r0 *1 12.75,105.5 pfet
M$115 VOUT EAOUT VIN VIN pfet L=0.5U W=25U AS=6.25P AD=6.25P PS=25.5U PD=25.5U
* device instance $116 r0 *1 13.75,105.5 pfet
M$116 VIN EAOUT VOUT VIN pfet L=0.5U W=25U AS=6.25P AD=6.25P PS=25.5U PD=25.5U
* device instance $117 r0 *1 14.75,105.5 pfet
M$117 VOUT EAOUT VIN VIN pfet L=0.5U W=25U AS=6.25P AD=6.25P PS=25.5U PD=25.5U
* device instance $118 r0 *1 15.75,105.5 pfet
M$118 VIN EAOUT VOUT VIN pfet L=0.5U W=25U AS=6.25P AD=6.25P PS=25.5U PD=25.5U
* device instance $119 r0 *1 16.75,105.5 pfet
M$119 VOUT EAOUT VIN VIN pfet L=0.5U W=25U AS=6.25P AD=6.25P PS=25.5U PD=25.5U
* device instance $120 r0 *1 17.75,105.5 pfet
M$120 VIN EAOUT VOUT VIN pfet L=0.5U W=25U AS=6.25P AD=6.25P PS=25.5U PD=25.5U
* device instance $121 r0 *1 18.75,105.5 pfet
M$121 VOUT EAOUT VIN VIN pfet L=0.5U W=25U AS=6.25P AD=6.25P PS=25.5U PD=25.5U
* device instance $122 r0 *1 19.75,105.5 pfet
M$122 VIN EAOUT VOUT VIN pfet L=0.5U W=25U AS=6.25P AD=6.25P PS=25.5U PD=25.5U
* device instance $123 r0 *1 20.75,105.5 pfet
M$123 VOUT EAOUT VIN VIN pfet L=0.5U W=25U AS=6.25P AD=6.25P PS=25.5U PD=25.5U
* device instance $124 r0 *1 21.75,105.5 pfet
M$124 VIN EAOUT VOUT VIN pfet L=0.5U W=25U AS=6.25P AD=6.25P PS=25.5U PD=25.5U
* device instance $125 r0 *1 22.75,105.5 pfet
M$125 VOUT EAOUT VIN VIN pfet L=0.5U W=25U AS=6.25P AD=6.25P PS=25.5U PD=25.5U
* device instance $126 r0 *1 23.75,105.5 pfet
M$126 VIN EAOUT VOUT VIN pfet L=0.5U W=25U AS=6.25P AD=6.25P PS=25.5U PD=25.5U
* device instance $127 r0 *1 24.75,105.5 pfet
M$127 VOUT EAOUT VIN VIN pfet L=0.5U W=25U AS=6.25P AD=6.25P PS=25.5U PD=25.5U
* device instance $128 r0 *1 25.75,105.5 pfet
M$128 VIN EAOUT VOUT VIN pfet L=0.5U W=25U AS=6.25P AD=6.25P PS=25.5U PD=25.5U
* device instance $129 r0 *1 26.75,105.5 pfet
M$129 VOUT EAOUT VIN VIN pfet L=0.5U W=25U AS=6.25P AD=6.25P PS=25.5U PD=25.5U
* device instance $130 r0 *1 27.75,105.5 pfet
M$130 VIN EAOUT VOUT VIN pfet L=0.5U W=25U AS=6.25P AD=12.5P PS=25.5U PD=51U
* device instance $131 r0 *1 130,0 cap_cmomi
XD_$131 EAOUT MZ cap_cmomi PARAMS: W=170 L=30
* device instance $132 r0 *1 23.51,-95.595 rhigh
R$132 MZ G1 VSS 1576811.2 rhigh L=1159.42U W=1U
* device instance $133 r0 *1 55.63,-94.285 rhigh
R$133 VOUT FB VSS 278392 rhigh L=204.7U W=1U
* device instance $134 r0 *1 68.63,-94.285 rhigh
R$134 FB VSS VSS 278392 rhigh L=204.7U W=1U
.ENDS sg13cmos5l_ldo_core_cmos5l
