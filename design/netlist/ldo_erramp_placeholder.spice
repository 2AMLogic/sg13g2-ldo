* ldo_erramp_placeholder -- generated by design/netlist.py from design/ldo_erramp_placeholder.sch
* Do not edit: edit the schematic and re-run the export.
** sch_path: design/ldo_erramp_placeholder.sch
.subckt ldo_erramp_placeholder INP INN OUT VSS
*.PININFO INP:I INN:I OUT:O VSS:B
E1 OUT VSS INP INN 100k
.ends
