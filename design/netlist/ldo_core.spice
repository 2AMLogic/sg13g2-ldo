* ldo_core -- generated by design/netlist.py from design/ldo_core.sch
* Do not edit: edit the schematic and re-run the export.
** sch_path: design/ldo_core.sch
.subckt ldo_core VIN VOUT VSS VREF
*.PININFO VIN:B VOUT:B VSS:B VREF:I
XMpass VOUT EAOUT VIN VIN sg13_hv_pmos w=300u l=0.5u ng=1 m=1
Rtop VOUT FB 300k m=1
Rbot FB VSS 300k m=1
Xamp FB VREF EAOUT VSS ldo_erramp_placeholder
.ends

* expanding   symbol:  ldo_erramp_placeholder.sym # of pins=4
** sym_path: design/ldo_erramp_placeholder.sym
** sch_path: design/ldo_erramp_placeholder.sch
.subckt ldo_erramp_placeholder INP INN OUT VSS
*.PININFO INP:I INN:I OUT:O VSS:B
E1 OUT VSS INP INN 100k
.ends
