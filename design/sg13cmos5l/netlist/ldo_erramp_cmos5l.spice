* ldo_erramp_cmos5l -- generated by design/netlist.py from design/sg13cmos5l/ldo_erramp_cmos5l.sch
* Do not edit: edit the schematic and re-run the export.
** sch_path: design/sg13cmos5l/ldo_erramp_cmos5l.sch
.subckt ldo_erramp_cmos5l INP INN OUT VDD VSS IBIAS
*.PININFO INP:I INN:I OUT:O VDD:B VSS:B IBIAS:B
XMb0 IBIAS IBIAS VDD VDD sg13_hv_pmos w=5u l=2u ng=1 m=1
XMtail TAIL IBIAS VDD VDD sg13_hv_pmos w=5u l=2u ng=1 m=2
XMload2 OUT IBIAS VDD VDD sg13_hv_pmos w=5u l=2u ng=1 m=4
XMinp G1 INP TAIL TAIL sg13_hv_pmos w=20u l=1u ng=1 m=1
XMinn N1 INN TAIL TAIL sg13_hv_pmos w=20u l=1u ng=1 m=1
XMn2 G1 N1 VSS VSS sg13_hv_nmos w=5u l=1u ng=1 m=1
XMn1 N1 N1 VSS VSS sg13_hv_nmos w=5u l=1u ng=1 m=1
XMn3 OUT G1 VSS VSS sg13_hv_nmos w=20u l=1u ng=1 m=1
XCc OUT MZ cap_cmomi w=30e-6 l=30e-6 mmin=1 mmax=4 feed=double subblock=0 m=1 mm_ok=1
XRz MZ G1 VSS rhigh w=1e-6 l=5.3e-6 m=1 b=0
.ends
