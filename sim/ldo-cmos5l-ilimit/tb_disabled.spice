* sg13g2-ldo -- SG13CMOS5L current-limiter smoke deck: EN low parks the limiter
* (issue #165, DR-0017 section 6). A klt-sim CIRCUIT BODY. NOMINAL ONLY:
* tt / 27 C / VIN = 3.30 V (swept 3.2-3.4 so AT= can interpolate), EN = 0 V, no load.

.include "../../design/sg13cmos5l/netlist/ldo_core_cmos5l.spice"

* DC-only stand-in for cap_cmomi (open circuit in DC; Ccl is the limiter-loop
* dominant pole and plays no part in a DC operating point). Interface mirrors
* cap_cmomi.lib. No transient or AC result may be read from this deck.
.param none=0 same=1 double=2
.subckt cap_cmomi PLUS MINUS w=5e-6 l=5e-6 mmin=1 mmax=4 feed=double subblock=0 mm_ok=1
Cdc PLUS MINUS 1p
.ends cap_cmomi

Vin VIN 0 dc 3.30
Vref VREF 0 dc 0.90
Ibias IBIAS 0 dc 2u
Een EN 0 VIN 0 0
Vmeas VOUTPIN OUT dc 0
Iload OUT 0 dc 0
Xtop VIN VOUTPIN 0 VREF IBIAS EN ldo_core_cmos5l
