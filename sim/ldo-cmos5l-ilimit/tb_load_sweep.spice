* sg13g2-ldo -- SG13CMOS5L current-limiter smoke deck: load sweep on the
* closed-loop regulator (issue #165, DR-0017 "DC bench" item 5, no-engagement
* at 50 mA). A klt-sim CIRCUIT BODY. NOMINAL ONLY: tt / 27 C / VIN = 3.30 V.
*
* LOAD. A resistor whose conductance Gsw is the DC sweep variable, not an ideal
* current sink. With the limiter present, an ideal sink (even 1 mA, from
* scratch) converged to a non-physical state (VOUT about -18 V, Mpass held off
* by the limiter) that the pre-limiter core does not reach; see README.md
* "Findings". DR-0017's transient section makes the same choice (a resistor,
* because an ideal sink is non-physical near VOUT = 0).

.include "../../design/sg13cmos5l/netlist/ldo_core_cmos5l.spice"

* DC-only stand-in for cap_cmomi (open circuit in DC; Ccl is the limiter-loop
* dominant pole and plays no part in a DC operating point). Interface mirrors
* cap_cmomi.lib. No transient or AC result may be read from this deck.
.param none=0 same=1 double=2
.subckt cap_cmomi PLUS MINUS w=5e-6 l=5e-6 mmin=1 mmax=4 feed=double subblock=0 mm_ok=1
Cdc PLUS MINUS 1p
.ends cap_cmomi

Vin VIN 0 dc 3.30
Vref VREF 0 dc 0.90
Ibias IBIAS 0 dc 2u
Een EN 0 VIN 0 1
Vmeas VOUTPIN OUT dc 0
* i = G*V(OUT): R = 1/Gsw (Gsw = 0 is no load).
Vg GSW 0 dc 0
Bload OUT 0 I=v(out)*v(gsw)
Xtop VIN VOUTPIN 0 VREF IBIAS EN ldo_core_cmos5l
