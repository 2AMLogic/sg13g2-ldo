* ldo_core_ilim_tb -- TESTBENCH-LOCAL, generated by gen_core_with_ilimit.sh from
* design/sg13cmos5l/netlist/ldo_core_cmos5l.spice. Not a design cell: the core
* itself has no limiter (integration deferred to #190). Do not edit.
.subckt ldo_core_ilim_tb VIN VOUT VSS VREF IBIAS EN
*.PININFO VIN:B VOUT:B VSS:B VREF:I IBIAS:B EN:I
XMpass VOUT EAOUT VIN VIN sg13_hv_pmos w=2800u l=0.5u ng=1 m=1
XRtop VOUT FB VSS rhigh w=1e-6 l=25.43e-6 m=1 b=7
XRbot FB VSS VSS rhigh w=1e-6 l=25.43e-6 m=1 b=7
Xamp FB VREF EAOUT VIN VSS IBIAS EN ldo_erramp_cmos5l
XMen EAOUT EN VIN VIN sg13_hv_pmos w=40u l=0.5u ng=1 m=1
XMbdis IBIAS EN VIN VIN sg13_hv_pmos w=5u l=0.5u ng=1 m=1
Xilim VIN VOUT EAOUT IBIAS EN VSS ldo_ilimit_cmos5l
.ends
