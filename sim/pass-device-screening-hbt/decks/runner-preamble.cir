* sg13g2-ldo -- batch-fleet runner preamble for the HBT screening decks (#139).
*
* Widens ngspice's printed .meas mantissa (default 6 significant digits) to 10;
* klt reports the printed token verbatim and the fleet runner's klt predates
* options.ngspice_init, so the setting is made here, ahead of the analysis
* klt's own .control block. Formatting only. No OSDI preload: the HBT models
* (VBIC level 9, Gummel-Poon level 1) are native ngspice models.
.control
set measureprec=9
.endc
