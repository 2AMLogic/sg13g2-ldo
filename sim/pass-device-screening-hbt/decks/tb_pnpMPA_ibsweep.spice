* sg13g2-ldo -- HBT pass-device screening, pnpMPA (pnp), bench ibsweep (issue #139).
* GENERATED by sim/pass-device-screening-hbt/gen_decks.py -- do not edit;
* edit the generator and re-run it (`gen_decks.py --check` gates drift).
* A klt-sim CIRCUIT BODY: no analysis, no .end; klt sim adds the corner
* .lib card (hbt-corners.lib -> the PDK's cornerHBT.lib), .temp and the analysis.
* Methodology, topology reading and caveats: README.md.
.include "runner-preamble.cir"
* Swept source Vs carries log10(Ib/A); Bibn mirrors Ib as a node voltage so
* `.meas` can FIND it.  Every group is an independent DUT with its own
* fixed-Vce source and its own copy of the base current (Bib_*).
Vs vs 0 dc -3
Bibn ibn 0 V = 10^V(vs)
* group l50_v030: Vec=0.3 V, m=2
Ve_l50_v030 e_l50_v030 0 dc 0.3
Vc_l50_v030 c_l50_v030 0 dc 0
Bib_l50_v030 b_l50_v030 0 I = 10^V(vs)
Xq_l50_v030 c_l50_v030 b_l50_v030 e_l50_v030 pnpMPA a=100p p=40u m=2
* group l50_v100: Vec=1 V, m=2
Ve_l50_v100 e_l50_v100 0 dc 1
Vc_l50_v100 c_l50_v100 0 dc 0
Bib_l50_v100 b_l50_v100 0 I = 10^V(vs)
Xq_l50_v100 c_l50_v100 b_l50_v100 e_l50_v100 pnpMPA a=100p p=40u m=2
* group l50_v150: Vec=1.5 V, m=2
Ve_l50_v150 e_l50_v150 0 dc 1.5
Vc_l50_v150 c_l50_v150 0 dc 0
Bib_l50_v150 b_l50_v150 0 I = 10^V(vs)
Xq_l50_v150 c_l50_v150 b_l50_v150 e_l50_v150 pnpMPA a=100p p=40u m=2
* group l50_v183: Vec=1.83 V, m=2
Ve_l50_v183 e_l50_v183 0 dc 1.83
Vc_l50_v183 c_l50_v183 0 dc 0
Bib_l50_v183 b_l50_v183 0 I = 10^V(vs)
Xq_l50_v183 c_l50_v183 b_l50_v183 e_l50_v183 pnpMPA a=100p p=40u m=2
* group l100_v030: Vec=0.3 V, m=4
Ve_l100_v030 e_l100_v030 0 dc 0.3
Vc_l100_v030 c_l100_v030 0 dc 0
Bib_l100_v030 b_l100_v030 0 I = 10^V(vs)
Xq_l100_v030 c_l100_v030 b_l100_v030 e_l100_v030 pnpMPA a=100p p=40u m=4
* group l100_v100: Vec=1 V, m=4
Ve_l100_v100 e_l100_v100 0 dc 1
Vc_l100_v100 c_l100_v100 0 dc 0
Bib_l100_v100 b_l100_v100 0 I = 10^V(vs)
Xq_l100_v100 c_l100_v100 b_l100_v100 e_l100_v100 pnpMPA a=100p p=40u m=4
* group l100_v150: Vec=1.5 V, m=4
Ve_l100_v150 e_l100_v150 0 dc 1.5
Vc_l100_v150 c_l100_v150 0 dc 0
Bib_l100_v150 b_l100_v150 0 I = 10^V(vs)
Xq_l100_v150 c_l100_v150 b_l100_v150 e_l100_v150 pnpMPA a=100p p=40u m=4
* group l100_v183: Vec=1.83 V, m=4
Ve_l100_v183 e_l100_v183 0 dc 1.83
Vc_l100_v183 c_l100_v183 0 dc 0
Bib_l100_v183 b_l100_v183 0 I = 10^V(vs)
Xq_l100_v183 c_l100_v183 b_l100_v183 e_l100_v183 pnpMPA a=100p p=40u m=4
* group cell: Vec=1 V, m=1
Ve_cell e_cell 0 dc 1
Vc_cell c_cell 0 dc 0
Bib_cell b_cell 0 I = 10^V(vs)
Xq_cell c_cell b_cell e_cell pnpMPA a=100p p=40u m=1
