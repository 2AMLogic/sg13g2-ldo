* sg13g2-ldo -- HBT pass-device screening, npn13G2v (npn), bench vcesweep (issue #139).
* GENERATED by sim/pass-device-screening-hbt/gen_decks.py -- do not edit;
* edit the generator and re-run it (`gen_decks.py --check` gates drift).
* A klt-sim CIRCUIT BODY: no analysis, no .end; klt sim adds the corner
* .lib card (hbt-corners.lib -> the PDK's cornerHBT.lib), .temp and the analysis.
* Methodology, topology reading and caveats: README.md.
.include "runner-preamble.cir"
* Swept source Vsw drives the common collector rail cc;
* each group forces Ib = Ic/beta_f through its own current source and senses
* Ic through a 0 V source Vs_*.
Vsw cc 0 dc 1
* group l50_b1: m=2, Ib=0.05 A (beta_f=1)
Vs_l50_b1 cc c_l50_b1 dc 0
Ib_l50_b1 0 b_l50_b1 dc 0.05
Xq_l50_b1 c_l50_b1 b_l50_b1 0 0 npn13G2v Nx=10 selft=0 m=2
* group l50_b10: m=2, Ib=0.005 A (beta_f=10)
Vs_l50_b10 cc c_l50_b10 dc 0
Ib_l50_b10 0 b_l50_b10 dc 0.005
Xq_l50_b10 c_l50_b10 b_l50_b10 0 0 npn13G2v Nx=10 selft=0 m=2
* group l50_b20: m=2, Ib=0.0025 A (beta_f=20)
Vs_l50_b20 cc c_l50_b20 dc 0
Ib_l50_b20 0 b_l50_b20 dc 0.0025
Xq_l50_b20 c_l50_b20 b_l50_b20 0 0 npn13G2v Nx=10 selft=0 m=2
* group l50_b50: m=2, Ib=0.001 A (beta_f=50)
Vs_l50_b50 cc c_l50_b50 dc 0
Ib_l50_b50 0 b_l50_b50 dc 0.001
Xq_l50_b50 c_l50_b50 b_l50_b50 0 0 npn13G2v Nx=10 selft=0 m=2
* group l100_b1: m=4, Ib=0.1 A (beta_f=1)
Vs_l100_b1 cc c_l100_b1 dc 0
Ib_l100_b1 0 b_l100_b1 dc 0.1
Xq_l100_b1 c_l100_b1 b_l100_b1 0 0 npn13G2v Nx=10 selft=0 m=4
* group l100_b10: m=4, Ib=0.01 A (beta_f=10)
Vs_l100_b10 cc c_l100_b10 dc 0
Ib_l100_b10 0 b_l100_b10 dc 0.01
Xq_l100_b10 c_l100_b10 b_l100_b10 0 0 npn13G2v Nx=10 selft=0 m=4
* group l100_b20: m=4, Ib=0.005 A (beta_f=20)
Vs_l100_b20 cc c_l100_b20 dc 0
Ib_l100_b20 0 b_l100_b20 dc 0.005
Xq_l100_b20 c_l100_b20 b_l100_b20 0 0 npn13G2v Nx=10 selft=0 m=4
* group l100_b50: m=4, Ib=0.002 A (beta_f=50)
Vs_l100_b50 cc c_l100_b50 dc 0
Ib_l100_b50 0 b_l100_b50 dc 0.002
Xq_l100_b50 c_l100_b50 b_l100_b50 0 0 npn13G2v Nx=10 selft=0 m=4
