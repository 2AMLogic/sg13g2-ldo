* sg13g2-ldo -- HBT pass-device screening, npn13G2v (npn), bench ibsweep (issue #139).
* GENERATED by sim/pass-device-screening-hbt/gen_decks.py -- do not edit;
* edit the generator and re-run it (`gen_decks.py --check` gates drift).
* A klt-sim CIRCUIT BODY: no analysis, no .end; klt sim adds the corner
* .lib card (hbt-corners.lib -> the PDK's cornerHBT.lib), .temp and the analysis.
* Methodology, topology reading and caveats: README.md.
.include "runner-preamble.cir"
* Swept source Vs carries log10(Ib/A); Bibn mirrors Ib as a node voltage so
* `.meas` can FIND it.  Every group is an independent DUT with its own
* fixed-Vce source and its own copy of the base current (Bib_*).
Vs vs 0 dc -3
Bibn ibn 0 V = 10^V(vs)
* group l50_v030: Vce=0.3 V, m=2
Vc_l50_v030 c_l50_v030 0 dc 0.3
Bib_l50_v030 0 b_l50_v030 I = 10^V(vs)
Xq_l50_v030 c_l50_v030 b_l50_v030 0 0 npn13G2v Nx=10 selft=0 m=2
* group l50_v100: Vce=1 V, m=2
Vc_l50_v100 c_l50_v100 0 dc 1
Bib_l50_v100 0 b_l50_v100 I = 10^V(vs)
Xq_l50_v100 c_l50_v100 b_l50_v100 0 0 npn13G2v Nx=10 selft=0 m=2
* group l50_v150: Vce=1.5 V, m=2
Vc_l50_v150 c_l50_v150 0 dc 1.5
Bib_l50_v150 0 b_l50_v150 I = 10^V(vs)
Xq_l50_v150 c_l50_v150 b_l50_v150 0 0 npn13G2v Nx=10 selft=0 m=2
* group l50_v183: Vce=1.83 V, m=2
Vc_l50_v183 c_l50_v183 0 dc 1.83
Bib_l50_v183 0 b_l50_v183 I = 10^V(vs)
Xq_l50_v183 c_l50_v183 b_l50_v183 0 0 npn13G2v Nx=10 selft=0 m=2
* group l100_v030: Vce=0.3 V, m=4
Vc_l100_v030 c_l100_v030 0 dc 0.3
Bib_l100_v030 0 b_l100_v030 I = 10^V(vs)
Xq_l100_v030 c_l100_v030 b_l100_v030 0 0 npn13G2v Nx=10 selft=0 m=4
* group l100_v100: Vce=1 V, m=4
Vc_l100_v100 c_l100_v100 0 dc 1
Bib_l100_v100 0 b_l100_v100 I = 10^V(vs)
Xq_l100_v100 c_l100_v100 b_l100_v100 0 0 npn13G2v Nx=10 selft=0 m=4
* group l100_v150: Vce=1.5 V, m=4
Vc_l100_v150 c_l100_v150 0 dc 1.5
Bib_l100_v150 0 b_l100_v150 I = 10^V(vs)
Xq_l100_v150 c_l100_v150 b_l100_v150 0 0 npn13G2v Nx=10 selft=0 m=4
* group l100_v183: Vce=1.83 V, m=4
Vc_l100_v183 c_l100_v183 0 dc 1.83
Bib_l100_v183 0 b_l100_v183 I = 10^V(vs)
Xq_l100_v183 c_l100_v183 b_l100_v183 0 0 npn13G2v Nx=10 selft=0 m=4
* group cell: Vce=1 V, m=1
Vc_cell c_cell 0 dc 1
Bib_cell 0 b_cell I = 10^V(vs)
Xq_cell c_cell b_cell 0 0 npn13G2v Nx=10 selft=0 m=1
