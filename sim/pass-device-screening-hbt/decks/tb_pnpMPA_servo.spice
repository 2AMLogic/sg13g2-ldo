* sg13g2-ldo -- HBT pass-device screening, pnpMPA (pnp), bench servo (issue #139).
* GENERATED by sim/pass-device-screening-hbt/gen_decks.py -- do not edit;
* edit the generator and re-run it (`gen_decks.py --check` gates drift).
* A klt-sim CIRCUIT BODY: no analysis, no .end; klt sim adds the corner
* .lib card (hbt-corners.lib -> the PDK's cornerHBT.lib), .temp and the analysis.
* Methodology, topology reading and caveats: README.md.
.include "runner-preamble.cir"
* gminsteps=0 skips ngspice's dynamic-gmin homotopy and goes straight to source
* stepping. Probed at pnpMPA/servo typ/125C and wcs/125C: dynamic gmin stepping
* fails ("Warning: Dynamic gmin stepping failed") and source stepping then
* converges to the same DC point (every printed .meas identical). NOT applied to
* the npn13G2* decks: there it makes the solve fail (singular matrix).
.options gminsteps=0
* One DC point (dummy source Vz is only there to give `dc` something to step).
* Group k: Ib_k = clamp(G*(T-Ic), 0, Ibmax); Bibn_k mirrors it as a node voltage
* so `.meas` can FIND it. i(vc_k) = +Ic (sense source in series with the collector
* rail for the NPN, with the collector for the PNP).
Vz z 0 dc 0
Rz z 0 1k
* group l50_v030: Vce=0.3 V, target Ic=0.05 A, m=2, Ib clamp 0.075 A
Ve_l50_v030 e_l50_v030 0 dc 0.3
Vc_l50_v030 c_l50_v030 0 dc 0
Bib_l50_v030 b_l50_v030 0 I = max(0, min(0.075, 20*(0.05-i(vc_l50_v030))))
Xq_l50_v030 c_l50_v030 b_l50_v030 e_l50_v030 pnpMPA a=100p p=40u m=2
Bibn_l50_v030 ibn_l50_v030 0 V = max(0, min(0.075, 20*(0.05-i(vc_l50_v030))))
* group l50_v100: Vce=1 V, target Ic=0.05 A, m=2, Ib clamp 0.075 A
Ve_l50_v100 e_l50_v100 0 dc 1
Vc_l50_v100 c_l50_v100 0 dc 0
Bib_l50_v100 b_l50_v100 0 I = max(0, min(0.075, 20*(0.05-i(vc_l50_v100))))
Xq_l50_v100 c_l50_v100 b_l50_v100 e_l50_v100 pnpMPA a=100p p=40u m=2
Bibn_l50_v100 ibn_l50_v100 0 V = max(0, min(0.075, 20*(0.05-i(vc_l50_v100))))
* group l50_v150: Vce=1.5 V, target Ic=0.05 A, m=2, Ib clamp 0.075 A
Ve_l50_v150 e_l50_v150 0 dc 1.5
Vc_l50_v150 c_l50_v150 0 dc 0
Bib_l50_v150 b_l50_v150 0 I = max(0, min(0.075, 20*(0.05-i(vc_l50_v150))))
Xq_l50_v150 c_l50_v150 b_l50_v150 e_l50_v150 pnpMPA a=100p p=40u m=2
Bibn_l50_v150 ibn_l50_v150 0 V = max(0, min(0.075, 20*(0.05-i(vc_l50_v150))))
* group l50_v183: Vce=1.83 V, target Ic=0.05 A, m=2, Ib clamp 0.075 A
Ve_l50_v183 e_l50_v183 0 dc 1.83
Vc_l50_v183 c_l50_v183 0 dc 0
Bib_l50_v183 b_l50_v183 0 I = max(0, min(0.075, 20*(0.05-i(vc_l50_v183))))
Xq_l50_v183 c_l50_v183 b_l50_v183 e_l50_v183 pnpMPA a=100p p=40u m=2
Bibn_l50_v183 ibn_l50_v183 0 V = max(0, min(0.075, 20*(0.05-i(vc_l50_v183))))
* group l100_v030: Vce=0.3 V, target Ic=0.1 A, m=4, Ib clamp 0.15 A
Ve_l100_v030 e_l100_v030 0 dc 0.3
Vc_l100_v030 c_l100_v030 0 dc 0
Bib_l100_v030 b_l100_v030 0 I = max(0, min(0.15, 20*(0.1-i(vc_l100_v030))))
Xq_l100_v030 c_l100_v030 b_l100_v030 e_l100_v030 pnpMPA a=100p p=40u m=4
Bibn_l100_v030 ibn_l100_v030 0 V = max(0, min(0.15, 20*(0.1-i(vc_l100_v030))))
* group l100_v100: Vce=1 V, target Ic=0.1 A, m=4, Ib clamp 0.15 A
Ve_l100_v100 e_l100_v100 0 dc 1
Vc_l100_v100 c_l100_v100 0 dc 0
Bib_l100_v100 b_l100_v100 0 I = max(0, min(0.15, 20*(0.1-i(vc_l100_v100))))
Xq_l100_v100 c_l100_v100 b_l100_v100 e_l100_v100 pnpMPA a=100p p=40u m=4
Bibn_l100_v100 ibn_l100_v100 0 V = max(0, min(0.15, 20*(0.1-i(vc_l100_v100))))
* group l100_v150: Vce=1.5 V, target Ic=0.1 A, m=4, Ib clamp 0.15 A
Ve_l100_v150 e_l100_v150 0 dc 1.5
Vc_l100_v150 c_l100_v150 0 dc 0
Bib_l100_v150 b_l100_v150 0 I = max(0, min(0.15, 20*(0.1-i(vc_l100_v150))))
Xq_l100_v150 c_l100_v150 b_l100_v150 e_l100_v150 pnpMPA a=100p p=40u m=4
Bibn_l100_v150 ibn_l100_v150 0 V = max(0, min(0.15, 20*(0.1-i(vc_l100_v150))))
* group l100_v183: Vce=1.83 V, target Ic=0.1 A, m=4, Ib clamp 0.15 A
Ve_l100_v183 e_l100_v183 0 dc 1.83
Vc_l100_v183 c_l100_v183 0 dc 0
Bib_l100_v183 b_l100_v183 0 I = max(0, min(0.15, 20*(0.1-i(vc_l100_v183))))
Xq_l100_v183 c_l100_v183 b_l100_v183 e_l100_v183 pnpMPA a=100p p=40u m=4
Bibn_l100_v183 ibn_l100_v183 0 V = max(0, min(0.15, 20*(0.1-i(vc_l100_v183))))
* group cell_i100u: Vce=1 V, target Ic=0.0001 A, m=1, Ib clamp 0.00015 A
Ve_cell_i100u e_cell_i100u 0 dc 1
Vc_cell_i100u c_cell_i100u 0 dc 0
Bib_cell_i100u b_cell_i100u 0 I = max(0, min(0.00015, 20*(0.0001-i(vc_cell_i100u))))
Xq_cell_i100u c_cell_i100u b_cell_i100u e_cell_i100u pnpMPA a=100p p=40u m=1
Bibn_cell_i100u ibn_cell_i100u 0 V = max(0, min(0.00015, 20*(0.0001-i(vc_cell_i100u))))
* group cell_i1m: Vce=1 V, target Ic=0.001 A, m=1, Ib clamp 0.0015 A
Ve_cell_i1m e_cell_i1m 0 dc 1
Vc_cell_i1m c_cell_i1m 0 dc 0
Bib_cell_i1m b_cell_i1m 0 I = max(0, min(0.0015, 20*(0.001-i(vc_cell_i1m))))
Xq_cell_i1m c_cell_i1m b_cell_i1m e_cell_i1m pnpMPA a=100p p=40u m=1
Bibn_cell_i1m ibn_cell_i1m 0 V = max(0, min(0.0015, 20*(0.001-i(vc_cell_i1m))))
* group cell_i10m: Vce=1 V, target Ic=0.01 A, m=1, Ib clamp 0.015 A
Ve_cell_i10m e_cell_i10m 0 dc 1
Vc_cell_i10m c_cell_i10m 0 dc 0
Bib_cell_i10m b_cell_i10m 0 I = max(0, min(0.015, 20*(0.01-i(vc_cell_i10m))))
Xq_cell_i10m c_cell_i10m b_cell_i10m e_cell_i10m pnpMPA a=100p p=40u m=1
Bibn_cell_i10m ibn_cell_i10m 0 V = max(0, min(0.015, 20*(0.01-i(vc_cell_i10m))))
* group cell_i25m: Vce=1 V, target Ic=0.025 A, m=1, Ib clamp 0.0375 A
Ve_cell_i25m e_cell_i25m 0 dc 1
Vc_cell_i25m c_cell_i25m 0 dc 0
Bib_cell_i25m b_cell_i25m 0 I = max(0, min(0.0375, 20*(0.025-i(vc_cell_i25m))))
Xq_cell_i25m c_cell_i25m b_cell_i25m e_cell_i25m pnpMPA a=100p p=40u m=1
Bibn_cell_i25m ibn_cell_i25m 0 V = max(0, min(0.0375, 20*(0.025-i(vc_cell_i25m))))
