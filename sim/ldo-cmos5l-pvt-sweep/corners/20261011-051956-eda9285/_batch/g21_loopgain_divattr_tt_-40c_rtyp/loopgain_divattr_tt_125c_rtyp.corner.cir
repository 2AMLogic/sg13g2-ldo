* klt sim -- generated corner deck, do not edit
.lib /var/tmp/eda-job-klt-sim-dbefbd8c9ba9/inputs/corners.lib mos_tt__res_typ__cap_typ
.include /var/tmp/eda-job-klt-sim-dbefbd8c9ba9/inputs/netlist.cir
.temp 125
.meas ac liveness_vout FIND vm(vout) AT=1
.control
set filetype=ascii
ac dec 20 1 100meg
write /var/tmp/eda-job-klt-sim-dbefbd8c9ba9/outputs/artifacts/mos_tt__res_typ__cap_typ_novdd_125C/waveform.raw
quit
.endc
.end
