* generated by sim/ldo-cmos5l-pvt-sweep/batch_backend.py from dcsweep_tt_-40c_rtyp
.include "/tmp/dropout-campaign.f63zz4pu/work/osdi-preamble.cir"

.options tnom=27

.include "/home/ubuntu/GitHub/sg13g2-ldo/.loom/worktrees/issue-70/design/sg13cmos5l/netlist/ldo_core_cmos5l.spice"

Vin VIN 0 dc 3.30
Vref VREF 0 dc 0.90
Ibias IBIAS 0 dc 2u
Iload VOUT 0 dc 0.05
Cout VOUT 0 1u

Xtop VIN VOUT 0 VREF IBIAS VIN ldo_core_cmos5l
