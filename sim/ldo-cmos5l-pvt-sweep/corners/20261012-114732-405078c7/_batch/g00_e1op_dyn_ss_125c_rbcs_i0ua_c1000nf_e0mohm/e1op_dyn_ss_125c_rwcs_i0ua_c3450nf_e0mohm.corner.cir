* klt sim -- generated corner deck, do not edit
.lib /var/tmp/eda-job-klt-sim-f98b99d68a9e/inputs/corners.lib mos_ss__res_wcs__cap_typ__vcd135b7f9a57
.include /var/tmp/eda-job-klt-sim-f98b99d68a9e/inputs/netlist.cir
.temp 125
.meas dc liveness_vout FIND v(vout) AT=3.3
.control
set filetype=ascii
dc vin 3.299 3.301 0.001
write /var/tmp/eda-job-klt-sim-f98b99d68a9e/outputs/artifacts/mos_ss__res_wcs__cap_typ__vcd135b7f9a57_novdd_125C/waveform.raw
quit
.endc
.end
