* klt sim -- generated corner deck, do not edit
.lib /var/tmp/eda-job-klt-sim-f98b99d68a9e/inputs/corners.lib mos_ff__res_wcs__cap_typ__vd8858fa1d1a7
.include /var/tmp/eda-job-klt-sim-f98b99d68a9e/inputs/netlist.cir
.temp -40
.meas dc liveness_vout FIND v(vout) AT=3.3
.control
set filetype=ascii
dc vin 3.299 3.301 0.001
write /var/tmp/eda-job-klt-sim-f98b99d68a9e/outputs/artifacts/mos_ff__res_wcs__cap_typ__vd8858fa1d1a7_novdd_n40C/waveform.raw
quit
.endc
.end
