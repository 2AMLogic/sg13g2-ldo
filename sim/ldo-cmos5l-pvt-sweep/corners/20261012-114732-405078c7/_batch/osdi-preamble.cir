* generated by batch_backend.py: load the STAGED OSDI binaries (job inputs/),
* in the templates' pre_osdi order, and print the hashes of what loaded.
.control
pre_osdi inputs/psp103.osdi
pre_osdi inputs/psp103_nqs.osdi
pre_osdi inputs/mosvar.osdi
pre_osdi inputs/r3_cmc.osdi
pre_osdi inputs/cap_cmomi.osdi
pre_osdi inputs/cap_cmomf.osdi
shell sha256sum inputs/psp103.osdi inputs/psp103_nqs.osdi inputs/mosvar.osdi inputs/r3_cmc.osdi inputs/cap_cmomi.osdi inputs/cap_cmomf.osdi
.endc
