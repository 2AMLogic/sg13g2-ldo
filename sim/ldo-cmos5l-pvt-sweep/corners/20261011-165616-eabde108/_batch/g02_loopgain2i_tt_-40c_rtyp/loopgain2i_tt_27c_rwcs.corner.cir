* klt sim -- generated corner deck, do not edit
.lib /var/tmp/eda-job-klt-sim-e332268bdc00/inputs/corners.lib mos_tt__res_wcs__cap_typ
.include /var/tmp/eda-job-klt-sim-e332268bdc00/inputs/netlist.cir
.temp 27
.meas ac liveness_vout FIND vm(vout) AT=1
.control
set filetype=ascii
ac dec 20 1 1e10
write /var/tmp/eda-job-klt-sim-e332268bdc00/outputs/artifacts/mos_tt__res_wcs__cap_typ_novdd_27C/waveform.raw
quit
.endc
.end
