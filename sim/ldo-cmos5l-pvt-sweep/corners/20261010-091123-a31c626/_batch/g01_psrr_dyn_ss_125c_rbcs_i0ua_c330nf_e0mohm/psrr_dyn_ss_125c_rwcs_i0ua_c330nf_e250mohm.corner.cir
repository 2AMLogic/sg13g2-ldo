* klt sim -- generated corner deck, do not edit
.lib /var/tmp/eda-job-klt-sim-4742f4a08f98/inputs/corners.lib mos_ss__res_wcs__cap_typ__vf3ae0f852e88
.include /var/tmp/eda-job-klt-sim-4742f4a08f98/inputs/netlist.cir
.temp 125
.meas ac liveness_vout FIND vm(vout) AT=1
.control
set filetype=ascii
ac dec 20 1 100meg
write /var/tmp/eda-job-klt-sim-4742f4a08f98/outputs/artifacts/mos_ss__res_wcs__cap_typ__vf3ae0f852e88_novdd_125C/waveform.raw
quit
.endc
.end
