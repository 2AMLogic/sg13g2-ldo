* klt sim -- generated corner deck, do not edit
.lib /var/tmp/eda-job-klt-sim-4742f4a08f98/inputs/corners.lib mos_ff__res_bcs__cap_typ__vef4d90daf261
.include /var/tmp/eda-job-klt-sim-4742f4a08f98/inputs/netlist.cir
.temp 27
.meas ac liveness_vout FIND vm(vout) AT=1
.control
set filetype=ascii
ac dec 20 1 100meg
write /var/tmp/eda-job-klt-sim-4742f4a08f98/outputs/artifacts/mos_ff__res_bcs__cap_typ__vef4d90daf261_novdd_27C/waveform.raw
quit
.endc
.end
