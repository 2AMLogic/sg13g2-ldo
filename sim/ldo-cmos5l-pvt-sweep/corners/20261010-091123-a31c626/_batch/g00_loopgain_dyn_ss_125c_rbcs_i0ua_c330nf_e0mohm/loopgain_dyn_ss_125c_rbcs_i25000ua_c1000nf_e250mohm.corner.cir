* klt sim -- generated corner deck, do not edit
.lib /var/tmp/eda-job-klt-sim-90c2614832a7/inputs/corners.lib mos_ss__res_bcs__cap_typ__ve13f464c4b81
.include /var/tmp/eda-job-klt-sim-90c2614832a7/inputs/netlist.cir
.temp 125
.meas ac liveness_vout FIND vm(vout) AT=1
.control
set filetype=ascii
ac dec 20 1 100meg
write /var/tmp/eda-job-klt-sim-90c2614832a7/outputs/artifacts/mos_ss__res_bcs__cap_typ__ve13f464c4b81_novdd_125C/waveform.raw
quit
.endc
.end
