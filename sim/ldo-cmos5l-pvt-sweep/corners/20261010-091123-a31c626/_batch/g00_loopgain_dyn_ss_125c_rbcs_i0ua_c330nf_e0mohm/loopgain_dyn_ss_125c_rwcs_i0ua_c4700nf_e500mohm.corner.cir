* klt sim -- generated corner deck, do not edit
.lib /var/tmp/eda-job-klt-sim-90c2614832a7/inputs/corners.lib mos_ss__res_wcs__cap_typ__v0bf1b041487c
.include /var/tmp/eda-job-klt-sim-90c2614832a7/inputs/netlist.cir
.temp 125
.meas ac liveness_vout FIND vm(vout) AT=1
.control
set filetype=ascii
ac dec 20 1 100meg
write /var/tmp/eda-job-klt-sim-90c2614832a7/outputs/artifacts/mos_ss__res_wcs__cap_typ__v0bf1b041487c_novdd_125C/waveform.raw
quit
.endc
.end
