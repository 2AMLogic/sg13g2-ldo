* klt sim -- generated corner deck, do not edit
.lib /var/tmp/eda-job-klt-sim-90c2614832a7/inputs/corners.lib mos_ff__res_wcs__cap_typ__v8546247da91f
.include /var/tmp/eda-job-klt-sim-90c2614832a7/inputs/netlist.cir
.temp -40
.meas ac liveness_vout FIND vm(vout) AT=1
.control
set filetype=ascii
ac dec 20 1 100meg
write /var/tmp/eda-job-klt-sim-90c2614832a7/outputs/artifacts/mos_ff__res_wcs__cap_typ__v8546247da91f_novdd_n40C/waveform.raw
quit
.endc
.end
