* klt sim -- generated corner deck, do not edit
.lib /var/tmp/eda-job-klt-sim-da010154b7bd/inputs/corners.lib mos_ff__res_bcs__cap_typ__vb33047c9083b
.include /var/tmp/eda-job-klt-sim-da010154b7bd/inputs/netlist.cir
.temp 27
.meas ac liveness_vout FIND vm(vout) AT=1
.control
set filetype=ascii
ac dec 20 1 100meg
write /var/tmp/eda-job-klt-sim-da010154b7bd/outputs/artifacts/mos_ff__res_bcs__cap_typ__vb33047c9083b_novdd_27C/waveform.raw
quit
.endc
.end
