* klt sim -- generated corner deck, do not edit
.lib /var/tmp/eda-job-klt-sim-da010154b7bd/inputs/corners.lib mos_ff__res_wcs__cap_typ__v83c4b1cc2d91
.include /var/tmp/eda-job-klt-sim-da010154b7bd/inputs/netlist.cir
.temp -40
.meas ac liveness_vout FIND vm(vout) AT=1
.control
set filetype=ascii
ac dec 20 1 100meg
write /var/tmp/eda-job-klt-sim-da010154b7bd/outputs/artifacts/mos_ff__res_wcs__cap_typ__v83c4b1cc2d91_novdd_n40C/waveform.raw
quit
.endc
.end
