* klt sim -- generated corner deck, do not edit
.lib /var/tmp/eda-job-klt-sim-a2c441d4dd47/inputs/corners.lib mos_ff__res_wcs__cap_typ__v286b89afdcf6
.include /var/tmp/eda-job-klt-sim-a2c441d4dd47/inputs/netlist.cir
.temp -40
.meas ac liveness_vout FIND vm(vout) AT=1
.control
set filetype=ascii
ac dec 20 1 100meg
write /var/tmp/eda-job-klt-sim-a2c441d4dd47/outputs/artifacts/mos_ff__res_wcs__cap_typ__v286b89afdcf6_novdd_n40C/waveform.raw
quit
.endc
.end
