* klt sim -- generated corner deck, do not edit
.lib /var/tmp/eda-job-klt-sim-f33976ed5823/inputs/corners.lib mos_ff__res_wcs__cap_typ__va49631b35601
.include /var/tmp/eda-job-klt-sim-f33976ed5823/inputs/netlist.cir
.temp -40
.meas ac liveness_vout FIND vm(vout) AT=1
.control
pre_osdi /var/tmp/eda-job-klt-sim-f33976ed5823/inputs/psp103.osdi
pre_osdi /var/tmp/eda-job-klt-sim-f33976ed5823/inputs/psp103_nqs.osdi
pre_osdi /var/tmp/eda-job-klt-sim-f33976ed5823/inputs/mosvar.osdi
pre_osdi /var/tmp/eda-job-klt-sim-f33976ed5823/inputs/r3_cmc.osdi
pre_osdi /var/tmp/eda-job-klt-sim-f33976ed5823/inputs/cap_cmomi.osdi
pre_osdi /var/tmp/eda-job-klt-sim-f33976ed5823/inputs/cap_cmomf.osdi
save all
set filetype=ascii
ac dec 20 1 100meg
write /var/tmp/eda-job-klt-sim-f33976ed5823/outputs/artifacts/mos_ff__res_wcs__cap_typ__va49631b35601_novdd_n40C/waveform.raw
quit
.endc
.end
