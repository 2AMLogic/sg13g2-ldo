* klt sim -- generated corner deck, do not edit
.lib /var/tmp/eda-job-klt-sim-81d7294abe1f/inputs/corners.lib mos_ss__res_bcs__cap_typ__v6d05d8b6654d
.include /var/tmp/eda-job-klt-sim-81d7294abe1f/inputs/netlist.cir
.temp 125
.meas ac liveness_vout FIND vm(vout) AT=1
.control
set filetype=ascii
ac dec 20 1 100meg
write /var/tmp/eda-job-klt-sim-81d7294abe1f/outputs/artifacts/mos_ss__res_bcs__cap_typ__v6d05d8b6654d_novdd_125C/waveform.raw
quit
.endc
.end
