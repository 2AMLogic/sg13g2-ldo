* klt sim -- generated corner deck, do not edit
.lib /var/tmp/eda-job-klt-sim-cd983ed72b7f/inputs/corners.lib mos_ff__res_wcs__cap_typ__v4a2db5df4ecd
.include /var/tmp/eda-job-klt-sim-cd983ed72b7f/inputs/netlist.cir
.temp -40
.meas ac liveness_vout FIND vm(vout) AT=1
.control
set filetype=ascii
ac dec 20 1 100meg
write /var/tmp/eda-job-klt-sim-cd983ed72b7f/outputs/artifacts/mos_ff__res_wcs__cap_typ__v4a2db5df4ecd_novdd_n40C/waveform.raw
quit
.endc
.end
