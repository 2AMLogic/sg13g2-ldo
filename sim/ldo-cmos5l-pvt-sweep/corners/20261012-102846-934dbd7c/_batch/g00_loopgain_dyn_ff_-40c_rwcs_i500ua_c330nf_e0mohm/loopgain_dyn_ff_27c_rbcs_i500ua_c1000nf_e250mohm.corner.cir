* klt sim -- generated corner deck, do not edit
.lib /var/tmp/eda-job-klt-sim-3c6d26ca87be/inputs/corners.lib mos_ff__res_bcs__cap_typ__vd2b9c38a54df
.include /var/tmp/eda-job-klt-sim-3c6d26ca87be/inputs/netlist.cir
.temp 27
.meas ac liveness_vout FIND vm(vout) AT=1
.control
set filetype=ascii
ac dec 20 1 100meg
write /var/tmp/eda-job-klt-sim-3c6d26ca87be/outputs/artifacts/mos_ff__res_bcs__cap_typ__vd2b9c38a54df_novdd_27C/waveform.raw
quit
.endc
.end
