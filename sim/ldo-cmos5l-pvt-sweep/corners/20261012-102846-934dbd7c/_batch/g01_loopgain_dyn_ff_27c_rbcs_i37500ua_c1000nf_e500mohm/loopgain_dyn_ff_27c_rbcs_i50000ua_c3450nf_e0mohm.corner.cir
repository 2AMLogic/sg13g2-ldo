* klt sim -- generated corner deck, do not edit
.lib /var/tmp/eda-job-klt-sim-15af1e2d643c/inputs/corners.lib mos_ff__res_bcs__cap_typ__v45d42fb8bd09
.include /var/tmp/eda-job-klt-sim-15af1e2d643c/inputs/netlist.cir
.temp 27
.meas ac liveness_vout FIND vm(vout) AT=1
.control
set filetype=ascii
ac dec 20 1 100meg
write /var/tmp/eda-job-klt-sim-15af1e2d643c/outputs/artifacts/mos_ff__res_bcs__cap_typ__v45d42fb8bd09_novdd_27C/waveform.raw
quit
.endc
.end
