* klt sim -- generated corner deck, do not edit
.lib /var/tmp/eda-job-klt-sim-df0fbdd1f68b/inputs/corners.lib mos_fs__res_bcs__cap_typ
.include /var/tmp/eda-job-klt-sim-df0fbdd1f68b/inputs/netlist.cir
.temp -40
.meas dc liveness_vout FIND v(vout) AT=3.3
.control
set filetype=ascii
dc Vin 2.00 3.63 0.01 Iload 0 0.05 0.0125
write /var/tmp/eda-job-klt-sim-df0fbdd1f68b/outputs/artifacts/mos_fs__res_bcs__cap_typ_novdd_n40C/waveform.raw
quit
.endc
.end
