* klt sim -- generated corner deck, do not edit
.lib /var/tmp/eda-job-klt-sim-a87026e9b536/inputs/corners.lib mos_ss__res_wcs__cap_typ
.include /var/tmp/eda-job-klt-sim-a87026e9b536/inputs/netlist.cir
.temp 125
.meas dc liveness_vout FIND v(vout) AT=3.3
.control
pre_osdi /var/tmp/eda-job-klt-sim-a87026e9b536/inputs/psp103.osdi
pre_osdi /var/tmp/eda-job-klt-sim-a87026e9b536/inputs/psp103_nqs.osdi
pre_osdi /var/tmp/eda-job-klt-sim-a87026e9b536/inputs/mosvar.osdi
pre_osdi /var/tmp/eda-job-klt-sim-a87026e9b536/inputs/r3_cmc.osdi
pre_osdi /var/tmp/eda-job-klt-sim-a87026e9b536/inputs/cap_cmomi.osdi
pre_osdi /var/tmp/eda-job-klt-sim-a87026e9b536/inputs/cap_cmomf.osdi
save all
set filetype=ascii
dc vin 3.299 3.301 0.001
write /var/tmp/eda-job-klt-sim-a87026e9b536/outputs/artifacts/mos_ss__res_wcs__cap_typ_novdd_125C/waveform.raw
quit
.endc
.end
