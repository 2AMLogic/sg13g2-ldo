* klt sim -- generated corner deck, do not edit
.lib /var/tmp/eda-job-klt-sim-c0bf0d944b7c/inputs/corners.lib mos_ss__res_wcs__cap_typ
.include /var/tmp/eda-job-klt-sim-c0bf0d944b7c/inputs/netlist.cir
.temp 125
.meas ac liveness_vout FIND vm(vout) AT=1
.control
pre_osdi /var/tmp/eda-job-klt-sim-c0bf0d944b7c/inputs/psp103.osdi
pre_osdi /var/tmp/eda-job-klt-sim-c0bf0d944b7c/inputs/psp103_nqs.osdi
pre_osdi /var/tmp/eda-job-klt-sim-c0bf0d944b7c/inputs/mosvar.osdi
pre_osdi /var/tmp/eda-job-klt-sim-c0bf0d944b7c/inputs/r3_cmc.osdi
pre_osdi /var/tmp/eda-job-klt-sim-c0bf0d944b7c/inputs/cap_cmomi.osdi
pre_osdi /var/tmp/eda-job-klt-sim-c0bf0d944b7c/inputs/cap_cmomf.osdi
save all
set filetype=ascii
ac dec 20 1 100meg
write /var/tmp/eda-job-klt-sim-c0bf0d944b7c/outputs/artifacts/mos_ss__res_wcs__cap_typ_novdd_125C/waveform.raw
quit
.endc
.end
