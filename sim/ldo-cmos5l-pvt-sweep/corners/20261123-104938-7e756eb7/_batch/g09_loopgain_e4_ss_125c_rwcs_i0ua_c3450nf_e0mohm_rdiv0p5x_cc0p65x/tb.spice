* generated by sim/ldo-cmos5l-pvt-sweep/batch_backend.py from loopgain_e4_ss_125c_rwcs_i0ua_c3450nf_e0mohm_rdiv0p5x_cc0p65x

.options tnom=27

.include "/home/ubuntu/GitHub/sg13g2-ldo/.loom/worktrees/issue-315/sim/ldo-cmos5l-pvt-sweep/netlist-snapshots/20261123-104938-7e756eb7/design-netlist-e4/ldo_core_cmos5l_rdiv0p5x_cc0p65x.spice"

Vin VIN 0 dc 3.30
Vref VREF 0 dc 0.90 ac 0
Ibias IBIAS 0 dc 2u
Iload VOUT 0 dc 0
Cout VOUT 0 3.45u

Vgnd VSS 0 dc 0
XMpass VOUT EAOUT VIN VIN sg13_hv_pmos w=2800u l=0.5u ng=1 m=1
XRtop VOUT FB VSS rhigh w=1e-6 l=12.715e-6 m=1 b=7
XRbot FB VSS VSS rhigh w=1e-6 l=12.715e-6 m=1 b=7
Vbreak FB FBAMP 0 ac 1
Xamp FBAMP VREF EAOUT VIN VSS IBIAS EN ldo_erramp_cmos5l
XMen EAOUT EN VIN VIN sg13_hv_pmos w=40u l=0.5u ng=1 m=1
XMbdis IBIAS EN VIN VIN sg13_hv_pmos w=5u l=0.5u ng=1 m=1
Ven EN VIN dc 0
