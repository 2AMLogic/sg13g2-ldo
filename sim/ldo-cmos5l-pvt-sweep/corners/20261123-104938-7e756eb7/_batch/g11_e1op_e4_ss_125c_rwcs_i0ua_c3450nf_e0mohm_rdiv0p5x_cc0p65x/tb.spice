* generated by sim/ldo-cmos5l-pvt-sweep/batch_backend.py from e1op_e4_ss_125c_rwcs_i0ua_c3450nf_e0mohm_rdiv0p5x_cc0p65x

.options tnom=27

.include "/home/ubuntu/GitHub/sg13g2-ldo/.loom/worktrees/issue-315/sim/ldo-cmos5l-pvt-sweep/netlist-snapshots/20261123-104938-7e756eb7/design-netlist-e4/ldo_core_cmos5l_rdiv0p5x_cc0p65x.spice"

Vin VIN 0 dc 3.30
Vref VREF 0 dc 0.90 ac 0
Ibias IBIAS 0 dc 2u
Iload VOUT 0 dc 0
Cout VOUT 0 3.45u

Vgnd VSS 0 dc 0
XMpass VOUT EAOUT VIN VIN sg13_hv_pmos w=2800u l=0.5u ng=1 m=1
XRtop VOUT FB VSS rhigh w=1e-6 l=12.715e-6 m=1 b=7
XRbot FB VSS VSS rhigh w=1e-6 l=12.715e-6 m=1 b=7
Vbreak FB FBAMP 0 ac 1
Xamp FBAMP VREF EAOUT VIN VSS IBIAS EN ldo_erramp_cmos5l
XMen EAOUT EN VIN VIN sg13_hv_pmos w=40u l=0.5u ng=1 m=1
XMbdis IBIAS EN VIN VIN sg13_hv_pmos w=5u l=0.5u ng=1 m=1
Ven EN VIN dc 0

Erep REPTOP 0 VOUT 0 1.0
Vdivsense REPTOP REPT dc 0
XRrep_top REPT REPFB 0 rhigh w=1e-6 l=12.715e-6 m=1 b=7
XRrep_bot REPFB 0 0 rhigh w=1e-6 l=12.715e-6 m=1 b=7

.save v(vout) v(eaout) v(fb) v(fbamp) v(vref) v(en) v(ibias) v(xamp.g1) v(xamp.mz) v(xamp.n1) v(xamp.tail) v(xamp.enb) v(reptop) i(vdivsense) i(vin) i(vbreak) @n.xmpass.nsg13_hv_pmos[ids] @n.xmpass.nsg13_hv_pmos[gm] @n.xmpass.nsg13_hv_pmos[gds] @n.xmen.nsg13_hv_pmos[ids] @n.xmen.nsg13_hv_pmos[gm] @n.xmen.nsg13_hv_pmos[gds] @n.xmbdis.nsg13_hv_pmos[ids] @n.xmbdis.nsg13_hv_pmos[gm] @n.xmbdis.nsg13_hv_pmos[gds] @n.xamp.xmb0.nsg13_hv_pmos[ids] @n.xamp.xmb0.nsg13_hv_pmos[gm] @n.xamp.xmb0.nsg13_hv_pmos[gds] @n.xamp.xmtail.nsg13_hv_pmos[ids] @n.xamp.xmtail.nsg13_hv_pmos[gm] @n.xamp.xmtail.nsg13_hv_pmos[gds] @n.xamp.xmload2.nsg13_hv_pmos[ids] @n.xamp.xmload2.nsg13_hv_pmos[gm] @n.xamp.xmload2.nsg13_hv_pmos[gds] @n.xamp.xminp.nsg13_hv_pmos[ids] @n.xamp.xminp.nsg13_hv_pmos[gm] @n.xamp.xminp.nsg13_hv_pmos[gds] @n.xamp.xminn.nsg13_hv_pmos[ids] @n.xamp.xminn.nsg13_hv_pmos[gm] @n.xamp.xminn.nsg13_hv_pmos[gds] @n.xamp.xminvp.nsg13_hv_pmos[ids] @n.xamp.xminvp.nsg13_hv_pmos[gm] @n.xamp.xminvp.nsg13_hv_pmos[gds] @n.xamp.xmn1.nsg13_hv_nmos[ids] @n.xamp.xmn1.nsg13_hv_nmos[gm] @n.xamp.xmn1.nsg13_hv_nmos[gds] @n.xamp.xmn2.nsg13_hv_nmos[ids] @n.xamp.xmn2.nsg13_hv_nmos[gm] @n.xamp.xmn2.nsg13_hv_nmos[gds] @n.xamp.xmn3.nsg13_hv_nmos[ids] @n.xamp.xmn3.nsg13_hv_nmos[gm] @n.xamp.xmn3.nsg13_hv_nmos[gds] @n.xamp.xminvn.nsg13_hv_nmos[ids] @n.xamp.xminvn.nsg13_hv_nmos[gm] @n.xamp.xminvn.nsg13_hv_nmos[gds] @n.xamp.xmpd.nsg13_hv_nmos[ids] @n.xamp.xmpd.nsg13_hv_nmos[gm] @n.xamp.xmpd.nsg13_hv_nmos[gds] @n.xmpass.nsg13_hv_pmos[cgs] @n.xmpass.nsg13_hv_pmos[cgd] @n.xmpass.nsg13_hv_pmos[cdd] @n.xmpass.nsg13_hv_pmos[vth] @n.xamp.xmn3.nsg13_hv_nmos[cgs] @n.xamp.xmn3.nsg13_hv_nmos[cgd]
