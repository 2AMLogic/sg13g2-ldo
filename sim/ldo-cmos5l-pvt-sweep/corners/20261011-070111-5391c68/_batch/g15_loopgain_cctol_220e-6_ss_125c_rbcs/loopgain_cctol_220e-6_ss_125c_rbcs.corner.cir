* klt sim -- generated corner deck, do not edit
.lib /var/tmp/eda-job-klt-sim-c50fbed5a3ed/inputs/corners.lib mos_ss__res_bcs__cap_typ
.include /var/tmp/eda-job-klt-sim-c50fbed5a3ed/inputs/netlist.cir
.temp 125
.meas ac liveness_vout FIND vm(vout) AT=1
.control
set filetype=ascii
ac dec 20 1 1e10
write /var/tmp/eda-job-klt-sim-c50fbed5a3ed/outputs/artifacts/mos_ss__res_bcs__cap_typ_novdd_125C/waveform.raw
quit
.endc
.end
