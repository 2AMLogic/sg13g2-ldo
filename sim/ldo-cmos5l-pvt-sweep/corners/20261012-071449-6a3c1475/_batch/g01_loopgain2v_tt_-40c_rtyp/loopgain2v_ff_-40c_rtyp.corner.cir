* klt sim -- generated corner deck, do not edit
.lib /var/tmp/eda-job-klt-sim-552b450b900c/inputs/corners.lib mos_ff__res_typ__cap_typ
.include /var/tmp/eda-job-klt-sim-552b450b900c/inputs/netlist.cir
.temp -40
.meas ac liveness_vout FIND vm(vout) AT=1
.control
set filetype=ascii
ac dec 20 1 1e10
write /var/tmp/eda-job-klt-sim-552b450b900c/outputs/artifacts/mos_ff__res_typ__cap_typ_novdd_n40C/waveform.raw
quit
.endc
.end
