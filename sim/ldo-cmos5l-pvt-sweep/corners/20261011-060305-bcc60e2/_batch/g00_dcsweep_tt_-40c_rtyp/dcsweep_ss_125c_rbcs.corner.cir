* klt sim -- generated corner deck, do not edit
.lib /var/tmp/eda-job-klt-sim-caf90ab0666c/inputs/corners.lib mos_ss__res_bcs__cap_typ
.include /var/tmp/eda-job-klt-sim-caf90ab0666c/inputs/netlist.cir
.temp 125
.meas dc liveness_vout FIND v(vout) AT=3.3
.control
set filetype=ascii
dc Vin 2.00 3.63 0.01 Iload 0 0.05 0.0125
write /var/tmp/eda-job-klt-sim-caf90ab0666c/outputs/artifacts/mos_ss__res_bcs__cap_typ_novdd_125C/waveform.raw
quit
.endc
.end
