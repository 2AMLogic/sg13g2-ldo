* generated by sim/ldo-cmos5l-pvt-sweep/batch_backend.py from dcsweep_tt_-40c_rtyp
.include "/tmp/dropout-campaign.o0s9t4j5/work/osdi-preamble.cir"

.options tnom=27

.include "/tmp/s155/ctl/design/sg13cmos5l/netlist/ldo_core_cmos5l.spice"

Vin VIN 0 dc 3.30
Vref VREF 0 dc 0.90
Ibias IBIAS 0 dc 2u
Iload VOUT 0 dc 0.05
Cout VOUT 0 1u

Xtop VIN VOUT 0 VREF IBIAS VIN ldo_core_cmos5l
