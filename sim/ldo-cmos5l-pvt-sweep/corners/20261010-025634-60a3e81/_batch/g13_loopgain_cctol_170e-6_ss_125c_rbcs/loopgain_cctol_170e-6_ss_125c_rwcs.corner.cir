* klt sim -- generated corner deck, do not edit
.lib /var/tmp/eda-job-klt-sim-34dd9e5c577f/inputs/corners.lib mos_ss__res_wcs__cap_typ
.include /var/tmp/eda-job-klt-sim-34dd9e5c577f/inputs/netlist.cir
.temp 125
.meas ac liveness_vout FIND vm(vout) AT=1
.control
set filetype=ascii
ac dec 20 1 100meg
write /var/tmp/eda-job-klt-sim-34dd9e5c577f/outputs/artifacts/mos_ss__res_wcs__cap_typ_novdd_125C/waveform.raw
quit
.endc
.end
