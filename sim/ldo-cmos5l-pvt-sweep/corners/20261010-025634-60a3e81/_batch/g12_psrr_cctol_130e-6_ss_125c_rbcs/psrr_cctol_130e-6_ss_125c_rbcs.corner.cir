* klt sim -- generated corner deck, do not edit
.lib /var/tmp/eda-job-klt-sim-30659b6373ff/inputs/corners.lib mos_ss__res_bcs__cap_typ
.include /var/tmp/eda-job-klt-sim-30659b6373ff/inputs/netlist.cir
.temp 125
.meas ac liveness_vout FIND vm(vout) AT=1
.control
set filetype=ascii
ac dec 20 1 100meg
write /var/tmp/eda-job-klt-sim-30659b6373ff/outputs/artifacts/mos_ss__res_bcs__cap_typ_novdd_125C/waveform.raw
quit
.endc
.end
