* klt sim -- generated corner deck, do not edit
.lib /var/tmp/eda-job-klt-sim-0827047f9932/inputs/corners.lib mos_sf__res_typ__cap_typ
.include /var/tmp/eda-job-klt-sim-0827047f9932/inputs/netlist.cir
.temp -40
.meas ac liveness_vout FIND vm(vout) AT=1
.control
set filetype=ascii
ac dec 20 1 100meg
write /var/tmp/eda-job-klt-sim-0827047f9932/outputs/artifacts/mos_sf__res_typ__cap_typ_novdd_n40C/waveform.raw
quit
.endc
.end
