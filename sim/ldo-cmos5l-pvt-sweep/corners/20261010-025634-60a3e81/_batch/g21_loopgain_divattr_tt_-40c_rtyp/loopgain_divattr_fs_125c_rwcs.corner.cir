* klt sim -- generated corner deck, do not edit
.lib /var/tmp/eda-job-klt-sim-8d6b4d9d563b/inputs/corners.lib mos_fs__res_wcs__cap_typ
.include /var/tmp/eda-job-klt-sim-8d6b4d9d563b/inputs/netlist.cir
.temp 125
.meas ac liveness_vout FIND vm(vout) AT=1
.control
set filetype=ascii
ac dec 20 1 100meg
write /var/tmp/eda-job-klt-sim-8d6b4d9d563b/outputs/artifacts/mos_fs__res_wcs__cap_typ_novdd_125C/waveform.raw
quit
.endc
.end
