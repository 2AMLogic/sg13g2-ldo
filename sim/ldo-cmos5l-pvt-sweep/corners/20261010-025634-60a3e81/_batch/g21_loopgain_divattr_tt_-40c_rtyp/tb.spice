* generated by sim/ldo-cmos5l-pvt-sweep/batch_backend.py from loopgain_divattr_tt_-40c_rtyp
.include "/tmp/ldo-cmos5l-pvt-batch.Kju0I0/osdi-preamble.cir"

.options tnom=27

.include "/home/ubuntu/GitHub/sg13g2-ldo/.loom/worktrees/issue-67/design/sg13cmos5l/netlist/ldo_core_cmos5l.spice"

Vin VIN 0 dc 3.30
Vref VREF 0 dc 0.90 ac 0
Ibias IBIAS 0 dc 2u
Iload VOUT 0 dc 0.001
Cout VOUT 0 1u

Vgnd VSS 0 dc 0
XMpass VOUT EAOUT VIN VIN sg13_hv_pmos w=2800u l=0.5u ng=1 m=1
Rtop VOUT FB 300k m=1
Rbot FB VSS 300k m=1
Vbreak FB FBAMP 0 ac 1
Xamp FBAMP VREF EAOUT VIN VSS IBIAS ldo_erramp_cmos5l
XMen EAOUT EN VIN VIN sg13_hv_pmos w=40u l=0.5u ng=1 m=1
XMbdis IBIAS EN VIN VIN sg13_hv_pmos w=5u l=0.5u ng=1 m=1
Ven EN VIN dc 0
