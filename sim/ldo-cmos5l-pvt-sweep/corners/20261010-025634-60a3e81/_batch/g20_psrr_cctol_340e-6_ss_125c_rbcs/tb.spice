* generated by sim/ldo-cmos5l-pvt-sweep/batch_backend.py from psrr_cctol_340e-6_ss_125c_rbcs
.include "/tmp/ldo-cmos5l-pvt-batch.Kju0I0/osdi-preamble.cir"

.options tnom=27

.include "/home/ubuntu/GitHub/sg13g2-ldo/.loom/worktrees/issue-67/sim/ldo-cmos5l-pvt-sweep/netlist-snapshots/20261010-025634-60a3e81/design-netlist-cc-sensitivity/ldo_core_cmos5l_cctol_340e-6.spice"

Vin VIN 0 dc 3.30 ac 1
Vref VREF 0 dc 0.90 ac 0
Ibias IBIAS 0 dc 2u
Iload VOUT 0 dc 0.001
Cout VOUT 0 1u

Xtop VIN VOUT 0 VREF IBIAS VIN ldo_core_cmos5l
