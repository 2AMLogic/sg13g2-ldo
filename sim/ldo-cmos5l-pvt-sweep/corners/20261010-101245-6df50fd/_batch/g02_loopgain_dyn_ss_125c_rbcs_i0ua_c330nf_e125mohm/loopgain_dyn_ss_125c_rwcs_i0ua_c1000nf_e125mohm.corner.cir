* klt sim -- generated corner deck, do not edit
.lib /var/tmp/eda-job-klt-sim-9d2664242684/inputs/corners.lib mos_ss__res_wcs__cap_typ__v81c8397f7dce
.include /var/tmp/eda-job-klt-sim-9d2664242684/inputs/netlist.cir
.temp 125
.meas ac liveness_vout FIND vm(vout) AT=1
.control
set filetype=ascii
ac dec 20 1 100meg
write /var/tmp/eda-job-klt-sim-9d2664242684/outputs/artifacts/mos_ss__res_wcs__cap_typ__v81c8397f7dce_novdd_125C/waveform.raw
quit
.endc
.end
