* generated by sim/ldo-cmos5l-pvt-sweep/batch_backend.py from loopgain_dyn_ss_125c_rbcs_i0ua_c330nf_e125mohm
.include "/tmp/ldo-cmos5l-pvt-batch.P97ZzK/osdi-preamble.cir"

.options tnom=27

.include "/home/ubuntu/GitHub/sg13g2-ldo/.loom/worktrees/issue-64/design/sg13cmos5l/netlist/ldo_core_cmos5l.spice"

Vin VIN 0 dc 3.30
Vref VREF 0 dc 0.90 ac 0
Ibias IBIAS 0 dc 2u

Vgnd VSS 0 dc 0
XMpass VOUT EAOUT VIN VIN sg13_hv_pmos w=2800u l=0.5u ng=1 m=1
XRtop VOUT FB VSS rhigh w=1e-6 l=25.43e-6 m=1 b=7
XRbot FB VSS VSS rhigh w=1e-6 l=25.43e-6 m=1 b=7
Vbreak FB FBAMP 0 ac 1
Xamp FBAMP VREF EAOUT VIN VSS IBIAS ldo_erramp_cmos5l
XMen EAOUT EN VIN VIN sg13_hv_pmos w=40u l=0.5u ng=1 m=1
XMbdis IBIAS EN VIN VIN sg13_hv_pmos w=5u l=0.5u ng=1 m=1
Ven EN VIN dc 0
