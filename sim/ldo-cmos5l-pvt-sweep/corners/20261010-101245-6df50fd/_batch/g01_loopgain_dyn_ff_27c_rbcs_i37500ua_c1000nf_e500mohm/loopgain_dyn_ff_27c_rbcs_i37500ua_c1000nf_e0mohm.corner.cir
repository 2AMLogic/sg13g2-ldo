* klt sim -- generated corner deck, do not edit
.lib /var/tmp/eda-job-klt-sim-6cb81d8174d5/inputs/corners.lib mos_ff__res_bcs__cap_typ__v9ffadcaa5689
.include /var/tmp/eda-job-klt-sim-6cb81d8174d5/inputs/netlist.cir
.temp 27
.meas ac liveness_vout FIND vm(vout) AT=1
.control
set filetype=ascii
ac dec 20 1 100meg
write /var/tmp/eda-job-klt-sim-6cb81d8174d5/outputs/artifacts/mos_ff__res_bcs__cap_typ__v9ffadcaa5689_novdd_27C/waveform.raw
quit
.endc
.end
