* generated by sim/ldo-cmos5l-pvt-sweep/batch_backend.py from psrr_dyn_ss_125c_rbcs_i0ua_c330nf_e125mohm
.include "/tmp/ldo-cmos5l-pvt-batch.P97ZzK/osdi-preamble.cir"

.options tnom=27

.include "/home/ubuntu/GitHub/sg13g2-ldo/.loom/worktrees/issue-64/design/sg13cmos5l/netlist/ldo_core_cmos5l.spice"

Vin VIN 0 dc 3.30 ac 1
Vref VREF 0 dc 0.90 ac 0
Ibias IBIAS 0 dc 2u

Xtop VIN VOUT 0 VREF IBIAS VIN ldo_core_cmos5l
