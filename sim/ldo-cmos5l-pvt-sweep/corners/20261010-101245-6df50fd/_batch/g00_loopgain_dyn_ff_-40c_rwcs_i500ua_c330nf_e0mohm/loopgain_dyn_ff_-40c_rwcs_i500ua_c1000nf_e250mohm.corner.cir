* klt sim -- generated corner deck, do not edit
.lib /var/tmp/eda-job-klt-sim-616ce1bb3589/inputs/corners.lib mos_ff__res_wcs__cap_typ__vd2b9c38a54df
.include /var/tmp/eda-job-klt-sim-616ce1bb3589/inputs/netlist.cir
.temp -40
.meas ac liveness_vout FIND vm(vout) AT=1
.control
set filetype=ascii
ac dec 20 1 100meg
write /var/tmp/eda-job-klt-sim-616ce1bb3589/outputs/artifacts/mos_ff__res_wcs__cap_typ__vd2b9c38a54df_novdd_n40C/waveform.raw
quit
.endc
.end
