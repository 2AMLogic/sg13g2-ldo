* klt sim -- generated corner deck, do not edit
.lib /var/tmp/eda-job-klt-sim-c94e5878a984/inputs/corners.lib mos_ff__res_wcs__cap_typ__vf7c3db5fae84
.include /var/tmp/eda-job-klt-sim-c94e5878a984/inputs/netlist.cir
.temp -40
.meas ac liveness_vout FIND vm(vout) AT=1
.control
set filetype=ascii
ac dec 20 1 100meg
write /var/tmp/eda-job-klt-sim-c94e5878a984/outputs/artifacts/mos_ff__res_wcs__cap_typ__vf7c3db5fae84_novdd_n40C/waveform.raw
quit
.endc
.end
