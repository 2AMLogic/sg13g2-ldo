* generated by sim/ldo-cmos5l-pvt-sweep/batch_backend.py from psrr_ss_125c_rbcs
.include "/tmp/pr87-val/work/osdi-preamble.cir"

.options tnom=27

.include "/tmp/pr87-val/ldo_core_cmos5l.spice"

Vin VIN 0 dc 3.30 ac 1
Vref VREF 0 dc 0.90 ac 0
Ibias IBIAS 0 dc 2u
Iload VOUT 0 dc 0.001
Cout VOUT 0 1u

Xtop VIN VOUT 0 VREF IBIAS ldo_core_cmos5l
