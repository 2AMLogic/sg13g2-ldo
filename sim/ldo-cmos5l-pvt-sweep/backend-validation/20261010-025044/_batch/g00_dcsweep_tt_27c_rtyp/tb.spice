* generated by sim/ldo-cmos5l-pvt-sweep/batch_backend.py from dcsweep_tt_27c_rtyp
.include "/tmp/pr87-val/work/osdi-preamble.cir"

.options tnom=27

.include "/tmp/pr87-val/ldo_core_cmos5l.spice"

Vin VIN 0 dc 3.30
Vref VREF 0 dc 0.90
Ibias IBIAS 0 dc 2u
Iload VOUT 0 dc 0
Cout VOUT 0 1u

Xtop VIN VOUT 0 VREF IBIAS ldo_core_cmos5l

Erep REPTOP 0 VOUT 0 1.0
Vdivsense REPTOP REPT dc 0
XRrep_top REPT REPFB 0 rhigh w=1e-6 l=25.43e-6 m=1 b=7
XRrep_bot REPFB 0 0 rhigh w=1e-6 l=25.43e-6 m=1 b=7
