* klt sim -- generated corner deck, do not edit
.lib /var/tmp/eda-job-klt-sim-62503d26a57a/inputs/corners.lib mos_ff__res_wcs__cap_typ__vdf4ddbd70a4a
.include /var/tmp/eda-job-klt-sim-62503d26a57a/inputs/netlist.cir
.temp -40
.meas ac liveness_vout FIND vm(vout) AT=1
.control
set filetype=ascii
ac dec 20 1 100meg
write /var/tmp/eda-job-klt-sim-62503d26a57a/outputs/artifacts/mos_ff__res_wcs__cap_typ__vdf4ddbd70a4a_novdd_n40C/waveform.raw
quit
.endc
.end
