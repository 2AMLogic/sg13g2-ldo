* klt sim -- generated corner deck, do not edit
.lib /var/tmp/eda-job-klt-sim-62503d26a57a/inputs/corners.lib mos_ff__res_bcs__cap_typ__v8c5129e3822e
.include /var/tmp/eda-job-klt-sim-62503d26a57a/inputs/netlist.cir
.temp 27
.meas ac liveness_vout FIND vm(vout) AT=1
.control
set filetype=ascii
ac dec 20 1 100meg
write /var/tmp/eda-job-klt-sim-62503d26a57a/outputs/artifacts/mos_ff__res_bcs__cap_typ__v8c5129e3822e_novdd_27C/waveform.raw
quit
.endc
.end
