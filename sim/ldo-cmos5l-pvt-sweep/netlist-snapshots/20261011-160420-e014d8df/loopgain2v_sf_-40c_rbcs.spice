* sg13g2-ldo -- SG13CMOS5L loop-gain bench, two-injection VOLTAGE run (issue #135).
* Generated from
* sim/ldo-cmos5l-pvt-sweep/testbench/tb_loopgain2v_cmos5l.spice.tmpl by
* sim/ldo-cmos5l-pvt-sweep/run_loopgain2.sh -- do not edit a generated
* netlist-snapshots/*.spice file directly. Full methodology (the Middlebrook
* two-injection derivation, sign conventions and combination formula) is in
* sim/ldo-cmos5l-pvt-sweep/README.md "Loop-gain measurement method --
* two-injection (Middlebrook) reconstruction"; this header is a short pointer.
*
* Generated for: corner=mos_sf temp=-40C res=res_bcs
* cap=cap_typ Cc_w=170u (nominal)
* PDK: ihp-sg13cmos5l /home/ubuntu/share/pdk (see sim/pdk-cmos5l.json for the pinned release)
* OSDI models: /home/ubuntu/share/pdk/ihp-sg13cmos5l/libs.tech/ngspice/osdi (built by sim/tools/build-osdi.sh)
* Design netlist under test (frozen at this repo's git sha in the record):
*   /home/ubuntu/GitHub/sg13g2-ldo/.loom/worktrees/issue-135/design/sg13cmos5l/netlist/ldo_core_cmos5l.spice
*
* THIS DECK IS THE VOLTAGE-INJECTION HALF of the two-injection measurement.
* Its circuit is byte-for-byte the loop-broken bench of
* tb_loopgain_cmos5l.spice.tmpl (same flattened ldo_core_cmos5l body, same
* `Vbreak FB FBAMP 0 ac 1` series break -- run_sweep.sh's
* assert_loopgain_topology_sync() guards this template's copy too), but its
* .control block exports the COMPLEX probe responses v(fb) and v(fbamp)
* (real and imaginary parts) instead of the reduced -v(fb)/v(fbamp) ratio.
* The reconstruction (sim/ldo-cmos5l-pvt-sweep/loopgain2.py) needs the raw
* complex responses of BOTH injections to rebuild the loop gain without the
* single-injection method's zero-gate-current assumption:
*
*   Hv(s) = v(fbamp)/v(fb)          (this deck, voltage injection)
*   Hi(s) = -i_m/(1 + i_m), i_m = i(vmeas)  (tb_loopgain2i, current inj.)
*   T(s)  = (1 + Hi/Hv)/(1 + Hi)    (Middlebrook combination; L = -T here)
*
* With an ideal series voltage injection the ratio Hv alone equals the true
* loop transfer T only when the load side draws zero current (FBAMP = a
* MOSFET gate: true at DC, questionable at hundreds of MHz -- the exact
* question issue #135 asks). The current-injection half and the combination
* remove that assumption; see the 2i template header and the README for the
* derivation, and loopgain2.py for the reconstruction and its validation.
*
* THIS BENCH FLATTENS ldo_core_cmos5l ONE LEVEL, exactly like
* tb_loopgain_cmos5l.spice.tmpl, so the loop-break source can be inserted at
* FB. The XMpass/XRtop/XRbot/Xamp/XMen/XMbdis instantiation lines below are
* reproduced VERBATIM from design/sg13cmos5l/netlist/ldo_core_cmos5l.spice's
* ldo_core_cmos5l subckt body (only FB -> FBAMP on Xamp's first pin, plus the
* inserted Vbreak, differ) -- run_sweep.sh asserts this file's copy still
* matches the generated netlist's topology every run.
*
* Loop-gain sign convention (same as the single-injection bench): Loop Gain
* L(s) = -T(s) = -v(fb)/v(fbamp), flipped so a healthy negative-feedback loop
* shows a large POSITIVE real L(0), phase near 0 at DC.
*
* ENABLE (issue #67, DR-0008): EN tied to VIN (enabled), as in every
* loop-gain bench of this experiment; see tb_loopgain_cmos5l.spice.tmpl's
* header for the enable-state argument.

.lib "/home/ubuntu/share/pdk/ihp-sg13cmos5l/libs.tech/ngspice/models/cornerMOShv.lib" mos_sf
.lib "/home/ubuntu/share/pdk/ihp-sg13cmos5l/libs.tech/ngspice/models/cornerRES.lib" res_bcs
.lib "/home/ubuntu/share/pdk/ihp-sg13cmos5l/libs.tech/ngspice/models/cornerCAP.lib" cap_typ

.options temp=-40 tnom=27

.include "/home/ubuntu/GitHub/sg13g2-ldo/.loom/worktrees/issue-135/design/sg13cmos5l/netlist/ldo_core_cmos5l.spice"

Vin VIN 0 dc 3.30
Vref VREF 0 dc 0.90 ac 0
Ibias IBIAS 0 dc 2u
* Operating point: the same defaults as the single-injection bench (issue #64
* substitutions; this campaign runs the legacy 1mA / 1uF / 0 ohm point).
Iload VOUT 0 dc 0.001
Cout VOUT 0 1u
* ESR=0: Cout wired directly to ground (campaign default)

* --- flattened ldo_core_cmos5l, loop broken at FB (see header). VSS is
* tied to global ground by the ideal 0V Vgnd source below (never aliased
* to node "0" directly in the four mirrored lines) so this block stays a
* byte-for-byte copy of ldo_core_cmos5l's subckt body, FB->FBAMP on Xamp's
* first pin excepted -- exactly what run_sweep.sh's
* assert_loopgain_topology_sync() diffs against the generated netlist. ---
Vgnd VSS 0 dc 0
XMpass VOUT EAOUT VIN VIN sg13_hv_pmos w=2800u l=0.5u ng=1 m=1
XRtop VOUT FB VSS rhigh w=1e-6 l=25.43e-6 m=1 b=7
XRbot FB VSS VSS rhigh w=1e-6 l=25.43e-6 m=1 b=7
Vbreak FB FBAMP 0 ac 1
Xamp FBAMP VREF EAOUT VIN VSS IBIAS EN ldo_erramp_cmos5l
XMen EAOUT EN VIN VIN sg13_hv_pmos w=40u l=0.5u ng=1 m=1
XMbdis IBIAS EN VIN VIN sg13_hv_pmos w=5u l=0.5u ng=1 m=1
* EN tied to VIN (enabled): Men's and Mbdis's gates sit at VIN, so both are
* off and contribute only drain junction/overlap loading (EAOUT, IBIAS);
* inside Xamp (issue #89) ENB sits at VSS, so the G1 pull-down Mpd is off
* and contributes only its drain loading and leakage on G1.
Ven EN VIN dc 0

.control
pre_osdi /home/ubuntu/share/pdk/ihp-sg13cmos5l/libs.tech/ngspice/osdi/psp103.osdi
pre_osdi /home/ubuntu/share/pdk/ihp-sg13cmos5l/libs.tech/ngspice/osdi/psp103_nqs.osdi
pre_osdi /home/ubuntu/share/pdk/ihp-sg13cmos5l/libs.tech/ngspice/osdi/mosvar.osdi
pre_osdi /home/ubuntu/share/pdk/ihp-sg13cmos5l/libs.tech/ngspice/osdi/r3_cmc.osdi
pre_osdi /home/ubuntu/share/pdk/ihp-sg13cmos5l/libs.tech/ngspice/osdi/cap_cmomi.osdi
pre_osdi /home/ubuntu/share/pdk/ihp-sg13cmos5l/libs.tech/ngspice/osdi/cap_cmomf.osdi

op
echo "LOOPGAIN2V_VOUT_OP $&v(vout)"

ac dec 20 1 1e10
* Raw complex probe responses for the two-injection reconstruction
* (loopgain2.py). wrdata writes one (freq, value) pair per vector, so this
* is an 8-column file: f, re v(fb), f, im v(fb), f, re v(fbamp), f, im
* v(fbamp). The batch fleet path rebuilds these columns from the corner's
* ASCII rawfile in batch_backend.py (wrdata_rows), which accepts ONLY this
* exact let block -- a template edit fails loudly there instead of being
* silently mistranslated.
let vfb_re = real(v(fb))
let vfb_im = imag(v(fb))
let vfbamp_re = real(v(fbamp))
let vfbamp_im = imag(v(fbamp))
wrdata /home/ubuntu/GitHub/sg13g2-ldo/.loom/worktrees/issue-135/sim/ldo-cmos5l-pvt-sweep/corners/20261011-160420-e014d8df/loopgain2v_sf_-40c_rbcs_ac.csv vfb_re vfb_im vfbamp_re vfbamp_im
.endc
.end
