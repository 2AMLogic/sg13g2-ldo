* generated by startup_campaign.py (ramp) from testbench/tb_startup_cmos5l.spice.tmpl
.include "../../osdi-preamble.cir"
* sg13g2-ldo -- SG13CMOS5L startup / enable transient bench (issue #69).
* Template rendered by startup_campaign.py into a klt-sim circuit BODY
* (klt adds the corner .lib, .temp and the .tran card). Methodology and
* limits: sim/ldo-cmos5l-pvt-sweep/README.md "Startup campaign (issue #69)".
* SCHEMATIC-LEVEL evidence for the EN-bearing core (DR-0008). It does not
* ratify DR-0007 row 9 and says nothing about layout.
*
* Design netlist under test: ../../../../../ldo-cmos5l-startup-ramp/core_with_ramp.spice
*
* Enable profile (one run, time zero of each case = EN = VIN/2 crossing):
*   0      .. 1 ms          EN = 0 (disabled; the DC operating point is solved
*                           with EN = 0, no UIC, VOUT is NOT forced to 0)
*   1 ms   + 1 us edge      EN 0 -> VIN         startup (observe >= 5 ms)
*   7 ms   + 1 us edge      EN VIN -> 0         disable
*   9 ms   + 1 us edge      EN 0 -> VIN         re-enable (observe >= 5 ms)
*   15 ms                   end
* The Cout bottom plate is wired by startup_campaign.py: straight to ground
* for ESR = 0, otherwise through a series resistor (never a 0-ohm resistor).
* The load is RESISTIVE (value from the 1.8 V target) so a disabled output is
* never dragged negative by a current sink. A load of 0 omits the resistor.

.options tnom=27

.include "../../../../../ldo-cmos5l-startup-ramp/core_with_ramp.spice"

Vin VIN 0 dc 3.63
Vref VREF 0 dc 0.90
Ibias IBIAS 0 dc 2u
* EN = VIN * CTL, so EN swings exactly 0 <-> VIN at whatever supply value klt
* alters Vin to (the supply axis); CTL carries the timing.
Vctl CTL 0 dc 0 pwl(0 0 1m 0 1.001m 1 7m 1 7.001m 0 9m 0 9.001m 1 15m 1)
Ben EN 0 v = 'v(vin)*v(ctl)'
* Rload omitted: load = 0 (output open)
Cout VOUT 0 330n
* ESR = 0: Cout wired straight to ground

Xtop VIN VOUT 0 VREF IBIAS EN ldo_core_cmos5l

* Keep only what the evaluator and the stress report read; saving every
* node would make the per-corner rawfile far larger than it is worth.
.save v(vout) v(en) v(vin) v(xtop.eaout) i(vin)
