* generated by startup_campaign.py (same construction as batch_backend.py):
* load the STAGED OSDI binaries (job inputs/) and print their hashes.
* set num_threads=1: the fleet runner starts one ngspice per corner in
* parallel; with OpenMP each of them spawns a full thread team, and
* transient runs then stall (150 s timeouts, 8 of 9 corners) instead of
* taking ~2 s. See README.md "Startup campaign" for the evidence.
.control
set num_threads=1
pre_osdi inputs/psp103.osdi
pre_osdi inputs/psp103_nqs.osdi
pre_osdi inputs/mosvar.osdi
pre_osdi inputs/r3_cmc.osdi
pre_osdi inputs/cap_cmomi.osdi
pre_osdi inputs/cap_cmomf.osdi
shell sha256sum inputs/psp103.osdi inputs/psp103_nqs.osdi inputs/mosvar.osdi inputs/r3_cmc.osdi inputs/cap_cmomi.osdi inputs/cap_cmomf.osdi
.endc
