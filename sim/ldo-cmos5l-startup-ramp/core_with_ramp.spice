* ldo_core_cmos5l (startup-ramp variant) -- TESTBENCH-LOCAL, generated by
* sim/ldo-cmos5l-startup-ramp/gen_core_with_ramp.py from
* design/sg13cmos5l/netlist/ldo_core_cmos5l.spice. NOT a design cell: the core
* on main has no soft start (issue #314, DR-0020 stays Proposed). Do not edit.
* ldo_core_cmos5l -- generated by design/netlist.py from design/sg13cmos5l/ldo_core_cmos5l.sch
* Do not edit: edit the schematic and re-run the export.
** sch_path: design/sg13cmos5l/ldo_core_cmos5l.sch
.subckt ldo_core_cmos5l VIN VOUT VSS VREF IBIAS EN
*.PININFO VIN:B VOUT:B VSS:B VREF:I IBIAS:B EN:I
XMpass VOUT EAOUT VIN VIN sg13_hv_pmos w=2800u l=0.5u ng=1 m=1
XRtop VOUT FB VSS rhigh w=1e-6 l=25.43e-6 m=1 b=7
XRbot FB VSS VSS rhigh w=1e-6 l=25.43e-6 m=1 b=7
Xamp FB VREFR EAOUT VIN VSS IBIAS EN ldo_erramp_cmos5l
XMen EAOUT EN VIN VIN sg13_hv_pmos w=40u l=0.5u ng=1 m=1
XMbdis IBIAS EN VIN VIN sg13_hv_pmos w=5u l=0.5u ng=1 m=1
* ---- TESTBENCH-LOCAL startup ramp (DR-0020 Candidate 2), not a design cell ----
XMrmp VREFR IBIAS VIN VIN sg13_hv_pmos w=1u l=20u ng=1 m=1
XCss VREFR VSS cap_cmomi w=96e-6 l=96e-6 mmin=1 mmax=4 feed=double subblock=0 m=1 mm_ok=1
XMrinvp RENB EN VIN VIN sg13_hv_pmos w=1u l=1u ng=1 m=1
XMrinvn RENB EN VSS VSS sg13_hv_nmos w=1u l=1u ng=1 m=1
XMrst VREFR RENB VSS VSS sg13_hv_nmos w=1u l=1u ng=1 m=1
Xclmp VREFR VREF CLG VIN VSS IBIAS EN ldo_erramp_cmos5l
XMclp VREFR CLG VSS VSS sg13_hv_nmos w=2u l=1u ng=1 m=1
* ---- end ramp ----
.ends

* expanding   symbol:  ldo_erramp_cmos5l.sym # of pins=7
** sym_path: design/sg13cmos5l/ldo_erramp_cmos5l.sym
** sch_path: design/sg13cmos5l/ldo_erramp_cmos5l.sch
.subckt ldo_erramp_cmos5l INP INN OUT VDD VSS IBIAS EN
*.PININFO INP:I INN:I OUT:O VDD:B VSS:B IBIAS:B EN:I
XMb0 IBIAS IBIAS VDD VDD sg13_hv_pmos w=5u l=2u ng=1 m=1
XMtail TAIL IBIAS VDD VDD sg13_hv_pmos w=5u l=2u ng=1 m=3
XMload2 OUT IBIAS VDD VDD sg13_hv_pmos w=5u l=2u ng=1 m=6
XMinp G1 INP TAIL TAIL sg13_hv_pmos w=20u l=1u ng=1 m=1
XMinn N1 INN TAIL TAIL sg13_hv_pmos w=20u l=1u ng=1 m=1
XMn2 G1 N1 VSS VSS sg13_hv_nmos w=5u l=1u ng=1 m=1
XMn1 N1 N1 VSS VSS sg13_hv_nmos w=5u l=1u ng=1 m=1
XMn3 OUT G1 VSS VSS sg13_hv_nmos w=20u l=1u ng=1 m=1
XCc OUT MZ cap_cmomi w=170e-6 l=30e-6 mmin=1 mmax=4 feed=double subblock=0 m=1 mm_ok=1
XRz MZ G1 VSS rhigh w=1e-6 l=28.81e-6 m=1 b=39
XMinvp ENB EN VDD VDD sg13_hv_pmos w=1u l=1u ng=1 m=1
XMinvn ENB EN VSS VSS sg13_hv_nmos w=1u l=1u ng=1 m=1
XMpd G1 ENB VSS VSS sg13_hv_nmos w=1u l=1u ng=1 m=1
.ends
.save v(xtop.vrefr)
